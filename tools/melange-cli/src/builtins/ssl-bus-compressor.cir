SSL 4000E Bus Compressor (Gyraf GSSL Rev 9)
* Converted from schemer pipeline transcription of SSL4044E schematic
* Original: cards 82E26/82E27, Gyraf Audio Rev #9 (06-2013)
* Stereo VCA compressor with feed-forward/feedback sidechain
*
* VCA gain law: G = exp(-Vc / 0.053), negative CV = gain reduction
* Audio VCAs: DBX202/THAT2180 (27K current-mode drive)
* Sidechain VCA: THAT2181 (summed L+R via 47K+47K)

* --- Device Models ---
* GBW models dominant pole: C_dom = AOL / (2π × GBW × ROUT)
* NE5534: GBW=10MHz, AOL=100dB → C_dom = 31.8nF
* TL074:  GBW=3MHz,  AOL=106dB → C_dom = 106nF
.model OA_NE5534 OA(AOL=100000 ROUT=50 VSAT=13 GBW=10MEG)
.model OA_NE5532 OA(AOL=100000 ROUT=100 VSAT=13 GBW=10MEG)
.model OA_TL074 OA(AOL=200000 ROUT=100 VSAT=11 GBW=3MEG)
.model OA_TL072 OA(AOL=200000 ROUT=100 VSAT=11 GBW=3MEG)
.model D1N4148 D(IS=2.52e-9 N=1.752 BV=100 IBV=100U CJO=4e-12)
.model DBX202 VCA(VSCALE=0.05298 G0=1.0 THD=0.002)
.model THAT2181 VCA(VSCALE=0.05298 G0=1.0)

* --- Power Supply (Norton equivalent DC sources) ---
Vpos   vcc15   0   DC 15
Vneg   vee15   0   DC -15
Vpos12 vcc12   0   DC 12
Vneg12 vee12   0   DC -12

* ============================================================
* LEFT INPUT BUFFER (NE5534 — differential to single-ended)
* ============================================================
Cin_lp  in  lin_ac_p  22U
Cin_ln  in_ln  lin_ac_n  22U
Cbyp_lp lin_ac_p 0  100N
Cbyp_ln lin_ac_n 0  100N
Rin_lp  lin_ac_p  lin_inv   22K
Rin_ln  lin_ac_n  lin_ninv  22K
Rbias_l lin_ninv  0   22K
U1  lin_ninv lin_inv lin_out OA_NE5534
Rfb_l   lin_out  lin_inv  22K
Cfb_l   lin_out  lin_inv  33P

* ============================================================
* RIGHT INPUT BUFFER (NE5534 — mirror of left)
* ============================================================
Cin_rp  in_rp  rin_ac_p  22U
Cin_rn  in_rn  rin_ac_n  22U
Cbyp_rp rin_ac_p 0  100N
Cbyp_rn rin_ac_n 0  100N
Rin_rp  rin_ac_p  rin_inv   22K
Rin_rn  rin_ac_n  rin_ninv  22K
Rbias_r rin_ninv  0   22K
U2  rin_ninv rin_inv rin_out OA_NE5534
Rfb_r   rin_out  rin_inv  22K
Cfb_r   rin_out  rin_inv  33P

* ============================================================
* LEFT AUDIO VCA (DBX202 / THAT 2180)
* sig+: lvca_in (via 27K from buffer, current-mode drive)
* sig-: liv_inv (I-V converter virtual ground)
* ctrl+: lvca_ctrl (1K from CV bus)
* ctrl-: ground
* ============================================================
Cvca_l  lin_out  lvca_in_ac  22U
Rdrive_l lvca_in_ac  lvca_in  27K
Rcv_l  cv_to_vcas  lvca_ctrl  1K
Rvca_l_ctrl lvca_ctrl 0 1MEG
Y1 lvca_in liv_inv lvca_ctrl 0 DBX202

* ============================================================
* LEFT I-V CONVERTER (1/2 NE5532)
* ============================================================
U3  liv_ninv liv_inv liv_out OA_NE5532
Rbias_liv liv_ninv 0  470
Rfb_liv  liv_out  liv_inv  15K
Cfb_liv  liv_out  liv_inv  100P

* ============================================================
* LEFT OUTPUT (1/2 NE5532 — balanced driver)
* ============================================================
Rout_lp  liv_out  lout_p_pre  100
Cout_lp  lout_p_pre  out  100U
Rbias_olp out  0  47K
Rinv_l   liv_out  linv_inv  10K
U4  0  linv_inv  linv_out OA_NE5532
Rfb_linv  linv_out  linv_inv  10K
Cfb_linv  linv_out  linv_inv  100P
Rout_ln   linv_out  lout_n_pre  100
Cout_ln   lout_n_pre  out_ln  100U
Rbias_oln out_ln  0  47K
Cbyp_lout lout_p_pre lout_n_pre  100N

* ============================================================
* RIGHT AUDIO VCA (DBX202 / THAT 2180 — mirror of left)
* ============================================================
Cvca_r  rin_out  rvca_in_ac  22U
Rdrive_r rvca_in_ac  rvca_in  27K
Rcv_r  cv_to_vcas  rvca_ctrl  1K
Rvca_r_ctrl rvca_ctrl 0 1MEG
Y2 rvca_in riv_inv rvca_ctrl 0 DBX202

* ============================================================
* RIGHT I-V CONVERTER (1/2 NE5532)
* ============================================================
U5  riv_ninv riv_inv riv_out OA_NE5532
Rbias_riv riv_ninv 0  470
Rfb_riv  riv_out  riv_inv  15K
Cfb_riv  riv_out  riv_inv  100P

* ============================================================
* RIGHT OUTPUT (1/2 NE5532 — balanced driver)
* ============================================================
Rout_rp  riv_out  rout_p_pre  100
Cout_rp  rout_p_pre  out_rp  100U
Rbias_orp out_rp  0  47K
Rinv_r   riv_out  rinv_inv  10K
U6  0  rinv_inv  rinv_out OA_NE5532
Rfb_rinv  rinv_out  rinv_inv  10K
Cfb_rinv  rinv_out  rinv_inv  100P
Rout_rn   rinv_out  rout_n_pre  100
Cout_rn   rout_n_pre  out_rn  100U
Rbias_orn out_rn  0  47K
Cbyp_rout rout_p_pre rout_n_pre  100N

* ============================================================
* SIDECHAIN SIGNAL SUMMING + THAT2181 (unity-gain current buffer)
* The THAT2181 operates at fixed unity gain (EC+/EC- both at -12V).
* It acts as a current buffer, not a variable-gain element.
* Threshold CV (cv_to_sc) is mixed into the summing node via 470R —
* it works by DC offset, not gain control.
* ============================================================
Rsc_l  lin_out  sc_sym  47K
Rsc_r  rin_out  sc_sym  47K
Rsc_cv  cv_to_sc  sc_sym  470
* THAT2181 at fixed unity gain — modeled as 1 ohm pass-through
Rsc_vca  sc_sym  sc_vca_out  1

* ============================================================
* SIDECHAIN BUFFER (TL074 Section B)
* Feedback: 33K || 100P — confirmed by user
* ============================================================
U7  0 sc_buf_inv sc_buf_out OA_TL074
Rsc_buf_in  sc_vca_out  sc_buf_inv  1
Rfb_sc_buf  sc_buf_out  sc_buf_inv  33K
Cfb_sc_buf  sc_buf_out  sc_buf_inv  100P
Csc_couple  sc_buf_out  sc_filt  22U
Csc_filt_byp  sc_filt  0  100N

* ============================================================
* FULL-WAVE PRECISION RECTIFIER (TL074 Sections A and D)
*
* Section A: half-wave rectifier
*   Pin 3 (+) at -12V, Pin 2 (-) = rect_a_inv
*   D1 clamp: anode=pin2, cathode=pin1
*   D2 output: anode=pin1, cathode=jct_b
*
* Section D: summing full-wave stage
*   Pin 12 (+) at -12V, Pin 13 (-) = rect_d_inv
*   D3: anode=d34_jct, cathode=pin14
*   D4: anode=pin14, cathode=d34_jct
*   D5: anode=pin14, cathode=node_c
* ============================================================

* Section A
Rrect_a_in   sc_filt    rect_a_inv  20K
U8  vee12 rect_a_inv rect_a_out OA_TL074
D1  rect_a_inv  rect_a_out  D1N4148
D2  rect_a_out  jct_b  D1N4148
Rfb_rect_a   jct_b  rect_a_inv  20K
Rrect_a_10k  jct_b  node_a  10K

* Section D
Rrect_d_in   sc_filt    rect_d_inv  20K
U9  vee12 rect_d_inv rect_d_out OA_TL074
Rfb_rect_d   d34_jct  rect_d_inv  1MEG
D3  d34_jct  rect_d_out  D1N4148
D4  rect_d_out  d34_jct  D1N4148
D5  rect_d_out  node_c  D1N4148

* ============================================================
* RATIO NETWORK (SW1: 2:1, 4:1, 10:1)
* 510K from wire "A", 270K from wire "B" (d34_jct)
* 68K from node_c, 3M9 from ratio_mid, D6 down
* 620K from node_c to +12V
* ============================================================
Rratio_510k  node_a  ratio_upper  510K
Rratio_270k  d34_jct  ratio_upper  270K
Rratio_68k   node_c  ratio_upper  68K
Rratio_3m9   ratio_mid  ratio_upper  3900K
D6  ratio_mid  node_c  D1N4148
Rratio_620k  node_c  vcc12  620K

* ============================================================
* METER (1mA GR meter — simplified)
* ============================================================
Rmeter_shunt  node_c  0  330
Rmeter_series node_c  meter_p  4700
Rmeter        meter_p  0  50

* ============================================================
* ATTACK (SW3)
* Positions: 820(0.1ms), 2K7(0.3ms), 8K2(1ms),
*            27K(3ms), 82K(10ms), 270K(30ms)
* ============================================================
Rattack  node_c  timing_node  8200
.switch Rattack 820 2700 8200 27000 82000 270000 "Attack"

* ============================================================
* RELEASE (SW4)
* Positions: 180K, 270K, 560K, 1M2 (all with 0.47uF cap)
* ============================================================
Rrelease  timing_node  rel_cap  270K
.switch Rrelease 180000 270000 560000 1200000 "Release"
Crelease  rel_cap  0  0.47U

* 3M3 from timing node to integrator input
Rtiming  timing_node  integ_inv  3300K

* ============================================================
* INTEGRATOR (TL074 Section C)
* 470K || 10P feedback — smoothed sidechain CV
* ============================================================
U10  0  integ_inv  node_d  OA_TL074
Rfb_integ  node_d  integ_inv  470K
Cfb_integ  node_d  integ_inv  10P

* ============================================================
* MAKEUP GAIN (1/2 TL072)
* 50KA pot: bottom=node_D, top=+12V via 120K
* Wiper → 620K → pin 6 summing junction
* Feedback: 100K || 100P
* Output: CV TO VCA'S (controls both audio DBX202 VCAs)
* ============================================================
Rmakeup_bias  vcc12  makeup_top  120K
* Pot at minimum (wiper near node_d) for unity gain at rest
* Turn CW to add makeup gain (compensate for compression)
Rpot_mk_a  makeup_top  makeup_wiper  49900
Rpot_mk_b  makeup_wiper  node_d  100
Rmakeup_620k makeup_wiper  cv_sum_mk  620K
U11  0  cv_sum_mk  cv_vca_pre  OA_TL072
Rfb_makeup  cv_vca_pre  cv_sum_mk  100K
Cfb_makeup  cv_vca_pre  cv_sum_mk  100P
Riso_mk  cv_vca_pre  cv_to_vcas  100
Ciso_mk  cv_to_vcas  0  100N

* ============================================================
* THRESHOLD (1/2 TL072)
* 50KA pot: top=+12V via 47K, bottom=-12V
* Wiper → 220K → summing junction
* Also: node_D → 100K → summing junction
* Feedback: 56K || 100P
* Output: CV TO SC (controls sidechain THAT2181 EC pins)
* ============================================================
Rthresh_47k   vcc12  thresh_top  47K
Rpot_th_a  thresh_top  thresh_wiper  25K
Rpot_th_b  thresh_wiper  vee12  25K
Rthresh_220k thresh_wiper  cv_sum_th  220K
Rthresh_100k node_d  cv_sum_th  100K
U12  0  cv_sum_th  cv_sc_pre  OA_TL072
Rfb_thresh  cv_sc_pre  cv_sum_th  56K
Cfb_thresh  cv_sc_pre  cv_sum_th  100P
Riso_th  cv_sc_pre  cv_to_sc  100
Ciso_th  cv_to_sc  0  100N

.END
