Tube Screamer TS808
* Ibanez TS-9 / TS808 style overdrive
* This implementation: Copyright (c) 2026 Melange Contributors
* License: MIT OR Apache-2.0
*
* Note: This is a clean-room implementation of a well-known
* circuit topology. "Tube Screamer" is a trademark of Ibanez.
*
* The key topology: an inverting op-amp stage with antiparallel
* diodes in the feedback loop. The diodes clip the signal at
* ~0.6V, creating the characteristic soft-clipping overdrive.
* The Drive pot controls input gain (R_drive), while R_fb sets
* the minimum feedback (clean headroom). The Tone pot is a
* simple RC lowpass after the clipping stage.

* --- Input coupling ---
Cin in n1 0.047u
R_pull in 0 1Meg

* --- Op-amp clipping stage (inverting amplifier with diode feedback) ---
* R_drive: input-to-inverting-input resistor (sets gain = R_fb / R_drive)
* R_fb: feedback resistor in parallel with clipping diodes
* D1, D2: antiparallel 1N4148 — THIS is what makes it a Tube Screamer
* U1: JRC4558 op-amp (non-inv=ground, inv=n2, out=n3)
*     With ideal op-amp and no rails, ground reference works directly.
R_drive n1 n2 51k
R_fb n2 n3 51k
D1 n3 n2 D1N4148
D2 n2 n3 D1N4148
U1 0 n2 n3 JRC4558

* --- Tone control ---
* Simple RC lowpass: R_tone + C_tone to ground
R_tone n3 n4 10k
C_tone n4 0 0.022u

* --- Output ---
C_out n4 out 0.1u
R_out out 0 1Meg

* --- Models ---
.model D1N4148 D(IS=2.52e-9 RS=0.568 N=1.752)
.model JRC4558 OA(AOL=200000 ROUT=75)

* --- Controls ---
.pot R_drive 4.7k 500k "Drive"
.pot R_tone 220 22k "Tone"

.END
