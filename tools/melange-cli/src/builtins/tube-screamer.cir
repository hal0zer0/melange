* Tube Screamer Style Overdrive
* Inspired by the Ibanez TS-9 circuit topology
* This implementation: Copyright (c) 2026 Melange Contributors
* License: MIT OR Apache-2.0
*
* Note: This is a clean-room implementation of a well-known
* circuit topology. "Tube Screamer" is a trademark of Ibanez.
*
* Simplified as a shunt diode clipper with input drive and tone.
* The original uses an op-amp for gain; this passive version
* achieves clipping through direct signal drive.

* Diode model - 1N4148 (classic TS9 clipping diode)
.model D1N4148 D(IS=2.52e-9 RS=0.568 N=1.752)

* Input coupling
C1 in n1 0.047u

* Input pulldown
R1 n1 0 1meg

* Drive resistor (controls clipping threshold)
R2 n1 n2 4.7k

* Anti-parallel silicon diodes for symmetric clipping
D1 n2 0 D1N4148
D2 0 n2 D1N4148

* Stability cap
C2 n2 0 100p

* Tone stack - simple RC lowpass
R3 n2 n3 10k
C3 n3 0 0.022u

* Output coupling
R4 n3 out 10k
C4 out 0 0.1u

* Output pulldown
R5 out 0 1meg

.END
