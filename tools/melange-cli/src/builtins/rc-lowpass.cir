* RC Lowpass Filter - Simple Test Circuit
* Copyright (c) 2026 Melange Contributors
* License: MIT OR Apache-2.0
*
* A basic first-order RC lowpass filter for testing the solver.
* Cutoff frequency: fc = 1/(2*pi*R*C) ≈ 159 Hz

* Input resistor
R1 in 1 10k

* Shunt capacitor
C1 1 0 0.1u

* Output
R2 1 out 10k

.END
