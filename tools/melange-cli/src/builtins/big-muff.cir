Big Muff Pi Style Fuzz
* Inspired by the Electro-Harmonix Big Muff Pi circuit topology
* This implementation: Copyright (c) 2026 Melange Contributors
* License: MIT OR Apache-2.0
*
* Note: This is a clean-room implementation of a well-known
* circuit topology. "Big Muff" is a trademark of Electro-Harmonix.
*
* 4-transistor fuzz with dual clipping stages
* Known for its "violin-like" sustain and harmonic richness

* Power supply
VCC vcc 0 9
* Bypass cap on supply rail
C_psu vcc 0 100u

* --- Input coupling ---
* High-impedance input with pulldown resistor
Cin in n1 0.1u
R_pull in 0 1Meg

* --- Stage 1: Input boost (Q1) ---
* Bias divider sets base at ~4.5V
R_b1a vcc base1 470k
R_b1b base1 0 470k
* AC-coupled input to base
C_b1 n1 base1 0.1u
* Common-emitter amplifier
Q1 coll1 base1 0 QNPN
R_c1 vcc coll1 100k
R_e1 emit1_unused 0 390

* --- Interstage coupling 1 to 2 ---
C_c1 coll1 n2 0.1u

* --- Stage 2: First clipping (Q2 + D1/D2) ---
* Bias divider
R_b2a vcc base2 470k
R_b2b base2 0 470k
* AC-coupled input to base
C_b2 n2 base2 0.1u
* CE amplifier
Q2 coll2 base2 0 QNPN
R_c2 vcc coll2 100k
* Antiparallel diodes from collector to ground — soft clipping
D1 coll2 0 D1N4148
D2 0 coll2 D1N4148
* Sustain control: lower R = more signal into clipping stage = more distortion
R_sust1 n2 base2 100k

* --- Interstage coupling 2 to 3 ---
C_c2 coll2 n3 0.1u

* --- Stage 3: Second clipping (Q3 + D3/D4) ---
* Bias divider
R_b3a vcc base3 470k
R_b3b base3 0 470k
* AC-coupled input to base
C_b3 n3 base3 0.1u
* CE amplifier
Q3 coll3 base3 0 QNPN
R_c3 vcc coll3 100k
* Antiparallel diodes from collector to ground — second clipping stage
D3 coll3 0 D1N4148
D4 0 coll3 D1N4148
* Sustain control: ganged with R_sust1
R_sust2 n3 base3 100k

* --- Tone stack (classic Big Muff mid-scoop) ---
* High-pass path through R_tone_hi
R_tone_hi coll3 tone_in 22k
* Low-pass path through C_tone_lo
C_tone_lo coll3 tone_out 3.9n
* Variable resistor blends high and low paths
R_tone tone_in tone_out 25k
* Shunt cap to ground on high-pass side
C_tone_hi tone_in 0 10n

* --- Stage 4: Output recovery (Q4) ---
* AC-coupled from tone stack output
C_b4 tone_out base4 0.1u
* Bias divider
R_b4a vcc base4 470k
R_b4b base4 0 470k
* CE amplifier
Q4 coll4 base4 0 QNPN
R_c4 vcc coll4 100k

* --- Output ---
C_out coll4 out 0.1u
R_out out 0 1Meg

* --- Device models ---
.model QNPN NPN(IS=1e-14 BF=300 NF=1 VAF=200 IKF=0.1 ISE=1e-12 NE=1.3 BR=2 NR=1 VAR=100 IKR=0.1 ISC=1e-12 NC=1.5 RB=5 RE=0.5 RC=0.5 CJE=15p CJC=8p)
.model D1N4148 D(IS=2.52e-9 RS=0.568 N=1.752 CJO=1.95p VJ=0.4 M=0.38 BV=100 IBV=1e-7)

* --- Controls ---
* Sustain: lower R shunts more signal into base, harder clipping
.pot R_sust1 10k 1Meg "Sustain"
* Tone: blends high-pass and low-pass paths (classic mid-scoop)
.pot R_tone 1k 100k "Tone"

.END
