* 1:1 shared-core saturating transformer, secondary open (golden coverage deck).
* 1 H windings, K=0.99, ISAT 10 mA on the primary. Loaded, the winding current
* is far above Isat while the core stays linear (Lenz); open, the magnetizing
* current saturates the core. Gated in saturation_knee_regression_tests.rs.
R_p in p 99
L_pri p 0 1 ISAT=10m
L_sec s 0 1
K1 L_pri L_sec 0.99
R_L s out 1m
R_load out 0 1MEG
.end
