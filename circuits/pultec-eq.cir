* Pultec EQP-1A Passive Equalizer
* Copyright (c) 2026 Melange Contributors
* License: MIT OR Apache-2.0
*
* Passive bridge-T EQ network followed by full tube amplifier stage:
*   HS-29 input coupling/phase splitter → 12AX7 (both sections, anti-phase) →
*   .25µF direct coupling → 12AU7 push-pull output → S-217-D output transformer
*
* Topology from Sowter schematic DWG E-72,658-2 (direct readings).
* Pot values from original Pultec EQP-1A service manual.
* Transformer specs from CineMag CM-S217D datasheet and Sowter 1475 data.
* 12AU7 Koren parameters from Sylvania Technical Manual fit.
*
* Signal flow (passive EQ is a 2-port network, NOT a series chain):
*
*   in ── R_in(620Ω) ── eq_in ──┬── R_hfb_u ── b ──┬── R_hfb_l ──┬── eq ──┬── R_hfc_u ── f ──┬── R_hfc_l ── mid ──┬── R_lfb ── gnd
*                               │                   │              │        │                   │                    │
*                               │                   ├── C+L+Q ─────┘        │                   ├── R_75 ── C_hfc ──┘├── C_lfb ── gnd
*                               │(600Ω src)         │(bridge-T boost)       │                   │(HF cut shunt)
*                               │                                           ├── C_lfa ── h ──── R2 ── out_tap ── R3 ── mid
*                               │                                           ├── R_lfc ── h     (HS-29 primary couples from out_tap)
*
* Amplifier stage:
*   out_tap → HS-29 primary (input coupling transformer) →
*   HS-29 CT secondary: pin 5 → grid1, pin 8 → grid2 (true push-pull anti-phase)
*   HS-29 CT (pins 6,7) → 43K DC return + 270pF HF bypass to ground
*   plate1/plate2 → .25µF → 12AU7 push-pull grids → plates →
*   360Ω stoppers → S-217-D output xfmr → out
*
* Feedback: S-217-D tertiary (pins 3-5, 1000Ω shunt) →
*   pin 3 → 360Ω → cathode (12AX7 pin 3)
*   pin 5 → 360Ω → cathode (12AX7 pin 8)
*   Both cathodes tied together. Series-voltage NFB → 0dB overall gain
*
* Controls (8 total — but 7 pots due to 3-terminal pot modeling):
*   3 switches: HF Boost Freq (7-pos), LF Freq (4-pos), HF Cut Freq (3-pos)
*   7 pots: HF Boost upper/lower (linked), Bandwidth, LF Boost, LF Atten,
*           HF Cut upper/lower (linked)
*
* 3-terminal pot note: HF Boost and HF Cut use voltage-divider pots where
* R_upper + R_lower = R_total. The plugin must link these inversely:
*   R_upper = R_total * (1 - param), R_lower = R_total * param
*
* Component values:
*   Pots: original Pultec manual (10k/2.5k/10k/100k/1k)
*   Fixed Rs: ABSounds analysis (R2=1k, R3=10k, R_q_off=390)
*   Switch caps/inductors: computed from ABSounds RATIO_L1_C1=12e6
*   LF caps: ABSounds (LoFreqC2 values, LoFreqC1 = LoFreqC2/30)
*   HF cut caps: ABSounds (270n/135n/68n for 5k/10k/20kHz)
*   HS-29: Sowter 1475 replacement data (130H primary, 1:1+1 CT)
*   S-217-D: CineMag CM-S217D datasheet (38.1H@1kHz, 4.474:1)
*   12AU7: Koren fit to Sylvania Technical Manual curves

.model 12AX7 TRIODE(MU=100 EX=1.4 KG1=1060 KP=600 KVB=300 CCG=1.6p CGP=1.7p CCP=0.46p)
* 12AU7 params from catalog (Koren fit to Sylvania datasheet)
.model 12AU7 TRIODE(MU=21.5 EX=1.3 KG1=1180 KP=84 KVB=300 CCG=2.3p CGP=2.2p CCP=0.5p)
.input_impedance 600

* B+ power supply — from Sowter schematic DWG E-72,658-2
* Real Pultec: 6X4 rectifier → +345V raw → 1000Ω/1W → +325V → filter caps.
* We model from +290V (measured at main filtered B+ node on schematic).
* Supply chain: +290V → 2200Ω/1W → Node G → 47kΩ → +250V (bias-only rail).
* Node G feeds PCC-55 passive EQ board.
* +250V rail supplies 12AX7 plate loads and 12AU7 grid bias network.
* Voltage annotations (11MΩ meter, no signal): +290V, +250V, +140V plate,
* +40V 12AU7 cathode, +31V grid bias, +1.3V 12AX7 cathode.
VCC vcc 0 DC 290

* B+ filter: +290V → 2200Ω → Node G (EQ board supply) → 47kΩ → +250V (bias)
R_drop vcc node_g 2200
C_filt node_g 0 40u
R_bias_filt node_g v250 47k

* === INPUT SERIES RESISTOR ===
* 620Ω between input transformer and passive EQ bridge (confirmed SIMetrix model).
R_in_series in eq_in 620
*
* === HF BOOST SECTION (bridge-T) ===
* 3-terminal 10k linear pot split into upper arm (eq_in→b) and lower arm (b→eq).
* Series LC resonant circuit + Q damping bridges from b to eq.
* Inductor values: VintageWindings measured taps from original Pultec unit.
* Bandwidth pot: 2.5k linear (confirmed SIMetrix model).
R_hfb_u eq_in b 10k
R_hfb_l b eq 10k
C_hfb b c_hfb 18n
L_hfb c_hfb d_hfb 156m
R_hfb_q d_hfb eq 2.5k
R_q_off d_hfb eq 390

* === HF CUT + LF SECTIONS (parallel paths from eq to mid) ===

* --- HF Cut path (eq → mid, bypasses the output tap) ---
* 75Ω series R between pot wiper and switched caps (confirmed SIMetrix model).
R_hfc_u eq f 1k
R_hfc_l f mid 1k
R_hfc_ser f hfc_cap 75
C_hfc hfc_cap mid 270n

* --- LF path (eq → out_tap → mid, includes the output tap) ---
* C_lfa independently selected per LF frequency position (NOT C_lfb/30 ratio).
* Real Pultec has non-constant ratios: 147:1 (20Hz) to 3.3:1 (100Hz).
C_lfa eq h 15n
R_lfc eq h 100k
R2 h out_tap 1k
R3 out_tap mid 10k

* === LF BOOST SHUNT (mid → ground) ===
R_lfb mid 0 10k
C_lfb mid 0 2.2u

* === INPUT COUPLING: TRIAD HS-29 TRANSFORMER ===
* 1:2 step-up phase splitter with center-tapped secondary.
* Construction: sec-pri-pri-sec (3600-1800-1800-3600 turns of #44 wire).
* Primary halves in series (pins 2-3 strapped): total 3600 turns.
* Each secondary half: 3600 turns (1:1 with full primary = 1:2 step-up).
* L_pri ≈ 37H (Sowter 9330 spec). BW: 5Hz-100kHz (-3dB).
*
* Pultec wiring (confirmed abbey road d enfer / GroupDIY + schemer):
*   Pin 4 = hot input (EQ output), Pin 1 = ground (reverse winding for HF)
*   Pin 5 → grid1, Pin 8 → grid2 (true push-pull anti-phase drive)
*   Pins 6,7 = center tap → 43K bias return + 270pF HF bypass
*   Pin 9 = electrostatic shield (ground)
*
* Primary (series, 3600 turns total): L = 37H
L_int_pri out_tap 0 37

* Secondary halves (each 3600 turns = full primary): L = 37H each.
* Differential grid drive = 2 × V_pri = +6dB voltage gain before tubes.
L_int_a grid1 hs29_ct 37
L_int_b hs29_ct grid2 37

* Coupling between primary and each secondary half, plus inter-secondary.
* All windings on same core — k_ab specified for NxN matrix positive definite.
K_inta L_int_pri L_int_a 0.99
K_intb L_int_pri L_int_b 0.99
K_intab L_int_a L_int_b 0.98

* Center tap: 43K DC return + 270pF HF bypass (from schematic).
* 43K provides grid bias reference (grid current ≈ 0, so V_grid ≈ 0V).
* 270pF bypasses HF to ground for stability.
R_ct_bias hs29_ct 0 43k
C_ct_bypass hs29_ct 0 270p

* === 12AX7 DUAL TRIODE (both sections, anti-phase) ===
* HS-29 CT secondary drives both grids directly in anti-phase.
* True push-pull: grid1 and grid2 receive equal and opposite signals.

* 12AX7 section 1 (pins 1,2,3)
T1a grid1 plate1 cathode 12AX7
* 12AX7 section 2 (pins 6,7,8)
T1b grid2 plate2 cathode 12AX7

* Plate load resistors (200K/1W from Node G, per schematic supply chain).
* "Node G feeds: 12AX7 plates (through 200K Ra)" — NOT from +250V rail.
* +250V rail supplies only bias divider and grid returns.
* Expected: plate ≈ node_g - 200K × 0.55mA ≈ 287 - 110 = +177V (schematic: +140V).
Ra1 node_g plate1 200k
Ra2 node_g plate2 200k

* 20pF anti-oscillation cap bridging the two 12AX7 plates.
* ".00002" on schematic = 0.00002µF = 20pF (same convention as ".00027" = 270pF).
* Previous 20nF was a 1000x error — 20nF with 200K plates gives f_c=80Hz, killing treble.
C_plate_bridge plate1 plate2 20p

* Shared cathode bias (820Ω to ground, unbypassed).
* Both cathodes (pins 3, 8) tied together. 820Ω to ground provides self-bias.
* S-217-D feedback tertiary connects to cathode through both 360Ω resistors.
* No cathode bypass cap — confirmed by schemer on both EQP-1A and EQP-1R.
Rk cathode 0 820

* === INTERSTAGE COUPLING: 12AX7 plates → 12AU7 grids ===
* .25µF caps provide direct AC coupling from 12AX7 plates to 12AU7 grids.
* f_c = 1/(2π × 1MΩ × 0.25µF) = 0.64 Hz — passes all audio.
C_coup2a plate1 grid2a 250n
C_coup2b plate2 grid2b 250n

* 12AU7 grid bias network — from Sowter schematic.
* +250V → 470kΩ → +31V bias node → 62kΩ → ground.
* Voltage divider: 250 × 62k/(470k+62k) = 29.1V ≈ +31V measured.
R_bias_hi v250 bias_31v 470k
R_bias_lo bias_31v 0 62k

* Grid return resistors (1MΩ each to +31V bias node).
* Sets grid DC at +31V; with cathode at +40V → Vgk ≈ -9V.
Rg2a grid2a bias_31v 1Meg
Rg2b grid2b bias_31v 1Meg
* 220pF grid-to-ground stabilization caps (standard fix for VHF oscillation
* in DIY Pultec builds — inter-winding capacitance in S-217-D creates 305kHz
* parasitic resonance. Sowter 9530 bifilar tertiary helps but caps still needed).
C_stab_a grid2a 0 220p
C_stab_b grid2b 0 220p

* === PUSH-PULL OUTPUT STAGE: 12AU7 (ECC82) ===
* Two triode sections driven in anti-phase by 12AX7 plates.
* Shared cathode node (+40V). Two matched 4.7kΩ in parallel (2.35kΩ effective)
* for current sharing ("4700* — * = RESISTORS SELECTED ALIKE").
* Two 50µF/50V bypass caps confirmed by schemer (not one 100µF).
T2a grid2a plate2a cath2 12AU7
T2b grid2b plate2b cath2 12AU7

* Shared cathode: two matched 4.7kΩ in parallel + two 50µF bypass caps
Rk2a cath2 0 4.7k
Rk2b cath2 0 4.7k
Ck2a cath2 0 50u
Ck2b cath2 0 50u

* Plate stopper resistors (360Ω each, from Sowter schematic).
* Prevent parasitic oscillation in push-pull output stage.
* Bridge 12AU7 plates to S-217-D primary.
R_stop2a plate2a opt_a 360
R_stop2b plate2b opt_b 360

* === OUTPUT TRANSFORMER: PEERLESS S-217-D ===
* Push-pull center-tapped primary, balanced secondary, feedback tertiary.
* Confirmed specs (CineMag CM-S217D reproduction):
*   Turns: 1575 (pri) : 71 (tert) : 352 (sec) per coil
*   Turns ratio: pri:sec = 4.474:1, pri:tert = 22.18:1, sec:tert = 4.96:1
*   Impedance: 12,000:600 ohm
*   L_pri = 38.1H at 1kHz (CineMag), ~220H at 30Hz (frequency-dependent permeability)
*   L_leak = 19mH → k = 0.9995
*
* Using 220H at 30Hz for LF accuracy (phase margin for NFB loop below 50Hz).
* Push-pull primary halves: L_each = 220/4 = 55H
* Secondary: L = L_pri_half × (N_sec/N_pri)² = 55 × (352/1575)² = 2.75H
* Tertiary: L = L_pri_half × (142/1575)² = 55 × 0.00813 = 0.447H
*
* B+ connects to center tap of primary (serves as plate load for 12AU7s).

* Center tap to B+ (low-R connection, transformer primary IS the plate load)
R_opt_ct vcc opt_ct 1m

* Push-pull primary halves (through winding DCR)
* DCR: 190Ω per primary half (CJ measurements, GroupDIY thread 51046)
R_dcr_a opt_a opt_a_w 190
R_dcr_b opt_b opt_b_w 190
L_opt_a opt_a_w opt_ct 55
L_opt_b opt_ct opt_b_w 55

* Secondary (through winding DCR)
* DCR: 18Ω (CJ measurements)
R_dcr_sec out_w out 18
L_opt_sec out_w 0 11

* Coupling between primary halves and secondary.
* K = sqrt(1 - L_leak/L_pri) = sqrt(1 - 0.019/38.1) = 0.99975
* (from CineMag CM-S217D L_leak=19mH, L_pri=38.1H at 1kHz).
* Previous K=0.95 created 195× too much leakage, causing -3dB at 89Hz.
* Augmented MNA solver handles K>0.95 (old companion model limitation removed).
K_opta L_opt_a L_opt_sec 0.999
K_optb L_opt_b L_opt_sec 0.999
K_optab L_opt_a L_opt_b 0.999

* === FEEDBACK: S-217-D TERTIARY WINDING (pins 3-5) ===
* Peerless winding data: 71 turns/coil × 2 coils = 142 turns total.
* L_tert = L_pri_half × (142/1575)² = 55 × 0.00813 = 0.447H (scaled with 220H primary).
* 1000Ω 1W shunt across pins 3-5 (confirmed on schematic).
*
* Feedback network (4 components, schematic-verified):
*   fb_s3 → 360Ω → cathode (series-voltage NFB)
*   fb_s5 → 360Ω → cathode (both to shared cathode, per Sowter schematic)
*   Provides ~0.8 dB common-mode NFB in a perfectly balanced push-pull.
*   Real hardware gets additional 1-3 dB from tube/transformer mismatch.
* Tertiary winding DCR: 17Ω (CJ measurements)
R_dcr_fb fb_s3_w fb_s3 17
L_fb_a fb_s5 fb_s3_w 447m
R_fb_shunt fb_s3 fb_s5 1000
R_fb_dcref fb_s5 0 1Meg
R_fb_a fb_s3 cathode 360
R_fb_b fb_s5 cathode 360
* Coupling: tertiary is bifilar with primary (K ≥ 0.999, CineMag spec).
K_fba L_opt_a L_fb_a 0.999
K_fbb L_opt_b L_fb_a 0.999
K_sec_fb L_opt_sec L_fb_a 0.999

* Output load — S-217-D spec: "OUTPUT TO 600Ω LOAD"
* The Pultec was designed for 600Ω terminated operation.
Rload out 0 600

* === SWITCH DIRECTIVES ===
* HF Boost frequency: 7 positions (ganged C + L)
* VintageWindings measured inductor taps from original Pultec unit.
* Caps matched for verified resonant frequencies (±0.2%).
* Positions: 3kHz, 4kHz, 5kHz, 8kHz, 10kHz, 12kHz, 16kHz
.switch C_hfb,L_hfb 18n/156m 18n/87.9m 15n/67.5m 8n2/48.2m 8n2/31.4m 5n6/31.4m 3n3/29.9m "HF Boost Freq"

* LF frequency: 4 positions (ganged boost cap C_lfb + atten cap C_lfa)
* Real Pultec uses independently selected cap pairs per frequency.
* Ratios range from 147:1 (20Hz) to 3.3:1 (100Hz) — NOT a constant ratio.
* Positions: 20Hz, 30Hz, 60Hz, 100Hz
.switch C_lfb,C_lfa 2.2u/15n 1u/22n 470n/47n 330n/100n "LF Freq"

* HF Cut frequency: 3 positions
* Positions: 5kHz, 10kHz, 20kHz
.switch C_hfc 270n 135n 68n "HF Cut Freq"

* === POTENTIOMETER DIRECTIVES ===
* HF Boost: 3-terminal 10k linear pot (upper + lower arms, link inversely)
* Pot minimums: 100Ω models physical wiper contact resistance.
* Pot defaults set to "flat" (all knobs at zero) position.
* Netlist nominals stay at max R for stable A_DEFAULT matrices.
* Plugin delta-stamps from nominal to default on first sample.
.pot R_hfb_u 100 10k 10k "HF Boost (upper)"
.pot R_hfb_l 100 10k 100 "HF Boost (lower)"
* Bandwidth/Q: 2.5k linear pot (series with 390Ω offset resistor R_q_off)
.pot R_hfb_q 100 2.5k 2.5k "Bandwidth"
* LF Boost: 10k audio pot (shunt from mid to ground)
.pot R_lfb 100 10k 100 "LF Boost"
* LF Atten: 100k audio pot (parallel with LF atten cap)
.pot R_lfc 100 100k 100 "LF Atten"
* HF Cut: 3-terminal 1k linear pot (upper + lower arms, link inversely)
* Default: wiper at mid side (no cut). R_hfc_u=max keeps eq isolated from cap.
.pot R_hfc_u 100 1k 1k "HF Cut (upper)"
.pot R_hfc_l 100 1k 100 "HF Cut (lower)"

.END
