* Pultec EQP-1A Passive Equalizer
* Copyright (c) 2026 Melange Contributors
* License: MIT OR Apache-2.0
*
* Passive bridge-T EQ network followed by full tube amplifier stage:
*   HS-29 input coupling/phase splitter → 12AX7 (both sections, anti-phase) →
*   .25µF direct coupling → 12AU7 push-pull output → S-217-D output transformer
*
* Topology from Sowter schematic DWG E-72,658-2 (direct readings).
* Pot values from original Pultec EQP-1A service manual.
* Transformer specs from CineMag CM-S217D datasheet and Sowter 1475 data.
* 12AU7 Koren parameters from Sylvania Technical Manual fit.
*
* Signal flow (passive EQ is a 2-port network, NOT a series chain):
*
*   in ──┬── R_hfb_u ── b ──┬── R_hfb_l ──┬── eq ──┬── R_hfc_u ── f ──┬── R_hfc_l ── mid ──┬── R_lfb ── gnd
*        │                   │              │        │                   │                    │
*        │                   ├── C+L+Q ─────┘        │                   ├── C_hfc ───────────┘├── C_lfb ── gnd
*        │(600Ω src)         │(bridge-T boost)       │                   │(HF cut shunt)
*        │                                           ├── C_lfa ── h ──── R2 ── out_tap ── R3 ── mid
*        │                                           ├── R_lfc ── h     (HS-29 primary couples from out_tap)
*
* Amplifier stage:
*   out_tap → HS-29 primary (input coupling/phase splitter) →
*   HS-29 CT secondary pin 5 → .00027 → grid1, 43K cross-coupling → grid2
*   HS-29 pin 8 = feedback node (bottom of 820Ω cathode resistor)
*   plate1/plate2 → .25µF → 12AU7 push-pull grids → plates →
*   360Ω stoppers → S-217-D output xfmr → out
*
* Feedback: S-217-D tertiary (pins 3-5, 1000Ω shunt) →
*   pin 3 → 360Ω → cathode (top of 820Ω)
*   pin 5 → 360Ω → fb_node (bottom of 820Ω = HS-29 pin 8)
*   Series-voltage NFB across cathode resistor → 0dB overall gain
*
* Controls (8 total — but 7 pots due to 3-terminal pot modeling):
*   3 switches: HF Boost Freq (7-pos), LF Freq (4-pos), HF Cut Freq (3-pos)
*   7 pots: HF Boost upper/lower (linked), Bandwidth, LF Boost, LF Atten,
*           HF Cut upper/lower (linked)
*
* 3-terminal pot note: HF Boost and HF Cut use voltage-divider pots where
* R_upper + R_lower = R_total. The plugin must link these inversely:
*   R_upper = R_total * (1 - param), R_lower = R_total * param
*
* Component values:
*   Pots: original Pultec manual (10k/2.5k/10k/100k/1k)
*   Fixed Rs: ABSounds analysis (R2=1k, R3=10k, R_q_off=390)
*   Switch caps/inductors: computed from ABSounds RATIO_L1_C1=12e6
*   LF caps: ABSounds (LoFreqC2 values, LoFreqC1 = LoFreqC2/30)
*   HF cut caps: ABSounds (270n/135n/68n for 5k/10k/20kHz)
*   HS-29: Sowter 1475 replacement data (130H primary, 1:1+1 CT)
*   S-217-D: CineMag CM-S217D datasheet (38.1H@1kHz, 4.474:1)
*   12AU7: Koren fit to Sylvania Technical Manual curves

.model 12AX7 TRIODE(MU=100 EX=1.4 KG1=1060 KP=600 KVB=300 CCG=1.6p CGP=1.7p CCP=0.46p)
* 12AU7 params from catalog (Koren fit to Sylvania datasheet)
.model 12AU7 TRIODE(MU=21.5 EX=1.3 KG1=1180 KP=84 KVB=300 CCG=2.3p CGP=2.2p CCP=0.5p)
.input_impedance 600

* B+ power supply — from Sowter schematic DWG E-72,658-2
* Real Pultec: 6X4 rectifier → +345V raw → 1000Ω/1W → +325V → filter caps.
* We model from +290V (measured at main filtered B+ node on schematic).
* Supply chain: +290V → 2200Ω/1W → Node G → 47kΩ → +250V (bias-only rail).
* Node G feeds PCC-55 passive EQ board.
* +250V rail supplies 12AX7 plate loads and 12AU7 grid bias network.
* Voltage annotations (11MΩ meter, no signal): +290V, +250V, +140V plate,
* +40V 12AU7 cathode, +31V grid bias, +1.3V 12AX7 cathode.
VCC vcc 0 DC 290

* B+ filter: +290V → 2200Ω → Node G (EQ board supply) → 47kΩ → +250V (bias)
R_drop vcc node_g 2200
C_filt node_g 0 40u
R_bias_filt node_g v250 47k

* === HF BOOST SECTION (bridge-T) ===
* 3-terminal 10k linear pot split into upper arm (in→b) and lower arm (b→eq).
* Series LC resonant circuit + Q damping bridges from b to eq.
* Inductor values: VintageWindings measured taps from original Pultec unit.
* Bandwidth pot: 2.2k (confirmed LTSpice + Sowter schematic).
R_hfb_u in b 10k
R_hfb_l b eq 10k
C_hfb b c_hfb 18n
L_hfb c_hfb d_hfb 156m
R_hfb_q d_hfb eq 2.2k
R_q_off d_hfb eq 390

* === HF CUT + LF SECTIONS (parallel paths from eq to mid) ===

* --- HF Cut path (eq → mid, bypasses the output tap) ---
R_hfc_u eq f 1k
R_hfc_l f mid 1k
C_hfc f mid 270n

* --- LF path (eq → out_tap → mid, includes the output tap) ---
* C_lfa independently selected per LF frequency position (NOT C_lfb/30 ratio).
* Real Pultec has non-constant ratios: 147:1 (20Hz) to 3.3:1 (100Hz).
C_lfa eq h 15n
R_lfc eq h 100k
R2 h out_tap 1k
R3 out_tap mid 10k

* === LF BOOST SHUNT (mid → ground) ===
R_lfb mid 0 10k
C_lfb mid 0 2.2u

* === INPUT COUPLING: TRIAD HS-29 TRANSFORMER ===
* Phase splitter: passive EQ output → center-tapped secondary drives
* both 12AX7 grids in anti-phase for push-pull drive.
* 1:1+1 center-tapped secondary (each half = primary turns).
* Confirmed specs: L_pri=130H, impedance 5k:20k, freq 20Hz-20kHz.
*
* Primary: EQ output drives transformer, winding to ground for DC return.
L_int_pri out_tap 0 130

* Secondary halves: center-tapped.
* Pin 5 (L_int_a) → .00027 → grid1 (forward signal path).
* Pin 8 (L_int_b) → fb_node (feedback injection point = bottom of 820Ω).
* Grid2 gets signal only through 43K cross-coupling from grid1.
L_int_a grid1 hs29_ct 130
L_int_b hs29_ct fb_node 130

* Coupling between primary and each secondary half, plus inter-secondary.
* All windings on same core — k_ab specified for NxN matrix positive definite.
K_inta L_int_pri L_int_a 0.99
K_intb L_int_pri L_int_b 0.99
K_intab L_int_a L_int_b 0.98

* Center tap grounded for DC return (provides grid bias reference)
R_ct hs29_ct 0 100

* === 12AX7 DUAL TRIODE (both sections, anti-phase) ===
* HS-29 CT secondary drives grids. 43K + .00027 cross-coupling network
* between grids (from schematic: HS-29 pin 5 → .00027 → 43K → pin 9).
C_gg grid1 mid_gg 270p
R_gg mid_gg grid2 43k

* 12AX7 section 1 (pins 1,2,3)
T1a grid1 plate1 cathode 12AX7
* 12AX7 section 2 (pins 6,7,8)
T1b grid2 plate2 cathode 12AX7

* Plate load resistors (200K/1W from +250V, confirmed from schematic).
* Both plates at ~+140V with Ip ≈ 0.55mA per section.
Ra1 v250 plate1 200k
Ra2 v250 plate2 200k

* 20nF anti-oscillation cap bridging the two 12AX7 plates.
* ".00002" on schematic = 20,000pF = 20nF. Confirmed by schemer.
C_plate_bridge plate1 plate2 20n

* Shared cathode bias (820Ω, unbypassed).
* Both cathodes tied together. 820Ω connects cathode to fb_node
* (NOT ground). DC path: cathode → 820Ω → fb_node → HS-29 winding → CT → 100Ω → GND.
* S-217-D feedback winding drives voltage across 820Ω for series NFB.
* No cathode bypass cap on schematic — NFB requires full signal across 820Ω.
Rk cathode fb_node 820

* === INTERSTAGE COUPLING: 12AX7 plates → 12AU7 grids ===
* .25µF caps provide direct AC coupling from 12AX7 plates to 12AU7 grids.
* f_c = 1/(2π × 1MΩ × 0.25µF) = 0.64 Hz — passes all audio.
C_coup2a plate1 grid2a 250n
C_coup2b plate2 grid2b 250n

* 12AU7 grid bias network — from Sowter schematic.
* +250V → 470kΩ → +31V bias node → 62kΩ → ground.
* Voltage divider: 250 × 62k/(470k+62k) = 29.1V ≈ +31V measured.
R_bias_hi v250 bias_31v 470k
R_bias_lo bias_31v 0 62k

* Grid return resistors (1MΩ each to +31V bias node).
* Sets grid DC at +31V; with cathode at +40V → Vgk ≈ -9V.
Rg2a grid2a bias_31v 1Meg
Rg2b grid2b bias_31v 1Meg

* === PUSH-PULL OUTPUT STAGE: 12AU7 (ECC82) ===
* Two triode sections driven in anti-phase by 12AX7 plates.
* Shared cathode node (+40V). Two matched 4.7kΩ in parallel (2.35kΩ effective)
* for current sharing ("4700* — * = RESISTORS SELECTED ALIKE").
* Two 50µF/50V bypass caps confirmed by schemer (not one 100µF).
T2a grid2a plate2a cath2 12AU7
T2b grid2b plate2b cath2 12AU7

* Shared cathode: two matched 4.7kΩ in parallel + two 50µF bypass caps
Rk2a cath2 0 4.7k
Rk2b cath2 0 4.7k
Ck2a cath2 0 50u
Ck2b cath2 0 50u

* Plate stopper resistors (360Ω each, from Sowter schematic).
* Prevent parasitic oscillation in push-pull output stage.
* Bridge 12AU7 plates to S-217-D primary.
R_stop2a plate2a opt_a 360
R_stop2b plate2b opt_b 360

* === OUTPUT TRANSFORMER: PEERLESS S-217-D ===
* Push-pull center-tapped primary, balanced secondary.
* Confirmed specs (CineMag CM-S217D reproduction):
*   Turns: 1575 (pri) : 352 (sec) per coil
*   Turns ratio: 4.474:1 (primary:secondary)
*   Impedance: 12,000:600 ohm
*   L_pri = 38.1H at 1kHz (CineMag measurement)
*   L_leak = 19mH → k = 0.9995
*
* Push-pull primary halves: L_each = L_total/4 = 9.525H
* Secondary: L = L_pri_half / N_half² = 9.525 / 2.237² = 1.903H
*
* B+ connects to center tap of primary (serves as plate load for 12AU7s).

* Center tap to B+ (low-R connection, transformer primary IS the plate load)
R_opt_ct vcc opt_ct 1m

* Push-pull primary halves
L_opt_a opt_a opt_ct 9.525
L_opt_b opt_ct opt_b 9.525

* Secondary (output)
L_opt_sec out 0 1.903

* Coupling between primary halves and secondary.
* Measured k ≈ 0.9998 (from L_leak=19mH, L_pri=38.1H) but k>0.95
* causes convergence failure in trapezoidal companion models for 3+
* winding transformers. Using k=0.95, validated in ngspice.
K_opta L_opt_a L_opt_sec 0.95
K_optb L_opt_b L_opt_sec 0.95
K_optab L_opt_a L_opt_b 0.95

* === FEEDBACK WINDING: S-217-D TERTIARY (pins 3-5) ===
* Series-voltage negative feedback from output back to 12AX7 cathode.
* Tertiary winding coupled to primary, with 1000Ω shunt damping.
* Pin 3 → 360Ω → cathode (top of 820Ω).
* Pin 5 → 360Ω → fb_node (bottom of 820Ω = HS-29 pin 8).
* Feedback voltage appears across 820Ω, reducing gain to ~0dB overall.
* +1.1V measured at pin 5 (close to cathode +1.3V, confirming DC connection).
*
* Tertiary inductance: estimated from turns ratio. If tertiary is ~1/4 of primary
* turns (feedback tap), L_tert ≈ L_pri/16 ≈ 2.4H. Using conservative estimate.
L_fb_a fb_s5 fb_s3 2.4
R_fb_shunt fb_s3 fb_s5 1000
* DC ground reference for tertiary (winding DC resistance)
R_fb_dcref fb_s5 0 1Meg
R_fb_a fb_s3 cathode 360
R_fb_b fb_s5 fb_node 360
* Coupling: tertiary to each primary half
K_fba L_opt_a L_fb_a 0.95
K_fbb L_opt_b L_fb_a 0.95
* Secondary-tertiary coupling (all windings on same core must couple)
K_sec_fb L_opt_sec L_fb_a 0.95

* Output load (high-impedance bridging, typical of modern equipment)
Rload out 0 100k

* === SWITCH DIRECTIVES ===
* HF Boost frequency: 7 positions (ganged C + L)
* VintageWindings measured inductor taps from original Pultec unit.
* Caps matched for verified resonant frequencies (±0.2%).
* Positions: 3kHz, 4kHz, 5kHz, 8kHz, 10kHz, 12kHz, 16kHz
.switch C_hfb,L_hfb 18n/156m 18n/87.9m 15n/67.5m 8n2/48.2m 8n2/31.4m 5n6/31.4m 3n3/29.9m "HF Boost Freq"

* LF frequency: 4 positions (ganged boost cap C_lfb + atten cap C_lfa)
* Real Pultec uses independently selected cap pairs per frequency.
* Ratios range from 147:1 (20Hz) to 3.3:1 (100Hz) — NOT a constant ratio.
* Positions: 20Hz, 30Hz, 60Hz, 100Hz
.switch C_lfb,C_lfa 2.2u/15n 1u/22n 470n/47n 330n/100n "LF Freq"

* HF Cut frequency: 3 positions
* Positions: 5kHz, 10kHz, 20kHz
.switch C_hfc 270n 135n 68n "HF Cut Freq"

* === POTENTIOMETER DIRECTIVES ===
* HF Boost: 3-terminal 10k linear pot (upper + lower arms, link inversely)
.pot R_hfb_u 1 10k "HF Boost (upper)"
.pot R_hfb_l 1 10k "HF Boost (lower)"
* Bandwidth/Q: 2.5k linear pot (series with 390Ω offset resistor R_q_off)
.pot R_hfb_q 1 2.2k "Bandwidth"
* LF Boost: 10k audio pot (shunt from mid to ground)
.pot R_lfb 1 10k "LF Boost"
* LF Atten: 100k audio pot (parallel with LF atten cap)
.pot R_lfc 1 100k "LF Atten"
* HF Cut: 3-terminal 1k linear pot (upper + lower arms, link inversely)
.pot R_hfc_u 1 1k "HF Cut (upper)"
.pot R_hfc_l 1 1k "HF Cut (lower)"

.END
