* Pultec EQP-1A Passive Equalizer
* Copyright (c) 2026 Melange Contributors
* License: MIT OR Apache-2.0
*
* Passive bridge-T EQ network followed by full tube amplifier stage:
*   12AX7 voltage amplifier → Triad HS-29 interstage transformer →
*   12AU7 push-pull output → Peerless S-217-D output transformer
*   with overall negative feedback via tertiary winding.
*
* Topology derived from ABSounds/EQP-WDF-1A analysis of actual hardware.
* Pot values from original Pultec EQP-1A service manual.
* Transformer specs from CineMag CM-S217D datasheet and Sowter 1475 data.
* 12AU7 Koren parameters from Sylvania Technical Manual fit.
*
* Signal flow (passive EQ is a 2-port network, NOT a series chain):
*
*   in ──┬── R_hfb_u ── b ──┬── R_hfb_l ──┬── eq ──┬── R_hfc_u ── f ──┬── R_hfc_l ── mid ──┬── R_lfb ── gnd
*        │                   │              │        │                   │                    │
*        │                   ├── C+L+Q ─────┘        │                   ├── C_hfc ───────────┘├── C_lfb ── gnd
*        │(600Ω src)         │(bridge-T boost)       │                   │(HF cut shunt)
*        │                                           ├── C_lfa ── h ──── R2 ── out_tap ── R3 ── mid
*        │                                           ├── R_lfc ── h     (tube Cin couples from out_tap)
*
* Output stage:
*   out_tap → Cin → 12AX7 grid → plate → Cint → HS-29 interstage xfmr →
*   push-pull 12AU7 grids → plates → S-217-D output xfmr → out
*   S-217-D tertiary → feedback to 12AX7 cathode (overall NFB)
*
* Controls (8 total — but 7 pots due to 3-terminal pot modeling):
*   3 switches: HF Boost Freq (7-pos), LF Freq (4-pos), HF Cut Freq (3-pos)
*   7 pots: HF Boost upper/lower (linked), Bandwidth, LF Boost, LF Atten,
*           HF Cut upper/lower (linked)
*
* 3-terminal pot note: HF Boost and HF Cut use voltage-divider pots where
* R_upper + R_lower = R_total. The plugin must link these inversely:
*   R_upper = R_total * (1 - param), R_lower = R_total * param
*
* Component values:
*   Pots: original Pultec manual (10k/2.5k/10k/100k/1k)
*   Fixed Rs: ABSounds analysis (R2=1k, R3=10k, R_q_off=390)
*   Switch caps/inductors: computed from ABSounds RATIO_L1_C1=12e6
*   LF caps: ABSounds (LoFreqC2 values, LoFreqC1 = LoFreqC2/30)
*   HF cut caps: ABSounds (270n/135n/68n for 5k/10k/20kHz)
*   HS-29: Sowter 1475 replacement data (130H primary, 1:1+1 CT)
*   S-217-D: CineMag CM-S217D datasheet (38.1H@1kHz, 4.474:1, tertiary 22.2:1)
*   12AU7: Koren fit to Sylvania Technical Manual curves

.model 12AX7 TRIODE(MU=100 EX=1.4 KG1=1060 KP=600 KVB=300)
.model 12AU7 TRIODE(MU=20.21 EX=1.23 KG1=1108.7 KP=84.96 KVB=551.3)
.input_impedance 600

* B+ power supply
* Real Pultec: 6X4 rectifier → 320V → two 1kΩ dropping resistors → 293V.
* Output transformer CT sees ~261V (measured). 12AX7 plate supply ~293V
* through Ra (100k), giving ~136V at plate (~1.5mA).
* We model the B+ at the output transformer CT (261V measured, 290V schematic).
* The 1kΩ dropping resistors and filter caps decouple the 12AX7 B+ supply.
* Voltage data: GroupDIY EQP-1A voltage measurements thread.
VCC vcc 0 DC 290

* B+ decoupling for 12AX7 (two 1kΩ/1W resistors + filter caps)
R_drop1 vcc vcc_filt 1k
C_filt1 vcc_filt 0 20u
R_drop2 vcc_filt vcc_ax7 1k
C_filt2 vcc_ax7 0 20u

* === HF BOOST SECTION (bridge-T) ===
* 3-terminal 10k linear pot split into upper arm (in→b) and lower arm (b→eq).
* Series LC resonant circuit + Q damping bridges from b to eq.
R_hfb_u in b 10k
R_hfb_l b eq 10k
C_hfb b c_hfb 15.3n
L_hfb c_hfb d_hfb 183.8m
R_hfb_q d_hfb eq 2.5k
R_q_off d_hfb eq 390

* === HF CUT + LF SECTIONS (parallel paths from eq to mid) ===

* --- HF Cut path (eq → mid, bypasses the output tap) ---
R_hfc_u eq f 1k
R_hfc_l f mid 1k
C_hfc f mid 270n

* --- LF path (eq → out_tap → mid, includes the output tap) ---
C_lfa eq h 73.3n
R_lfc eq h 100k
R2 h out_tap 1k
R3 out_tap mid 10k

* === LF BOOST SHUNT (mid → ground) ===
R_lfb mid 0 10k
C_lfb mid 0 2.2u

* === FIRST STAGE: 12AX7 VOLTAGE AMPLIFIER ===
* Coupling cap from EQ output tap to tube grid
Cin out_tap grid 100n

* Grid leak resistor
Rg grid 0 1Meg

* 12AX7 triode
T1 grid plate cathode 12AX7

* Plate load resistor (connected to filtered B+ rail)
Ra vcc_ax7 plate 100k

* Cathode bias with bypass cap
* Rk and Ck connect to feedback node (fb), not ground.
* The S-217-D tertiary winding provides DC return path to ground
* while injecting overall negative feedback at AC.
Rk cathode fb 1.5k
Ck cathode fb 25u

* === INTERSTAGE: TRIAD HS-29 TRANSFORMER ===
* Phase splitter: single-ended 12AX7 plate → push-pull drive for 12AU7 pair.
* 1:1+1 center-tapped secondary (each half = primary turns).
* Confirmed specs: L_pri=130H, impedance 5k:20k, freq 20Hz-20kHz.
* Coupling cap blocks DC from first stage plate.
Cint plate pri_int 1u

* Primary: pri_int to ground (DC return through winding)
L_int_pri pri_int 0 130

* Secondary halves: center-tapped for anti-phase push-pull drive.
* Node order sets polarity: grid2a in phase with primary, grid2b anti-phase.
L_int_a grid2a int_ct 130
L_int_b int_ct grid2b 130

* Coupling between primary and each secondary half
K_inta L_int_pri L_int_a 0.99
K_intb L_int_pri L_int_b 0.99

* Center tap bias: connected to B+ through ~2M bias resistor.
* Grid leaks (470k each, parallel 235k) provide ground return.
* Sets V_ct ≈ 290 × 235k/(2M+235k) ≈ 31V (measured on real unit).
* This biases 12AU7 grids to +31V, giving Vgk ≈ -9V with 40V cathode.
R_bias vcc int_ct 2Meg

* Grid leak resistors for push-pull 12AU7
Rg2a grid2a 0 470k
Rg2b grid2b 0 470k

* === PUSH-PULL OUTPUT STAGE: 12AU7 (ECC82) ===
* Two triode sections driven in anti-phase by HS-29 secondary.
* Shared cathode resistor cancels even harmonics in push-pull.
T2a grid2a plate2a cath2 12AU7
T2b grid2b plate2b cath2 12AU7

* Shared cathode bias (40V measured → ~4k at ~10mA push-pull current)
Rk2 cath2 0 4k
Ck2 cath2 0 100u

* === OUTPUT TRANSFORMER: PEERLESS S-217-D ===
* Push-pull center-tapped primary, balanced secondary, tertiary feedback.
* Confirmed specs (CineMag CM-S217D reproduction):
*   Turns: 1575 (pri) : 352 (sec) : 71 (tert) per coil
*   Turns ratio: 4.474:1 (primary:secondary)
*   Impedance: 12,000:600 ohm
*   L_pri = 38.1H at 1kHz (CineMag measurement)
*   L_leak = 19mH → k = 0.9995
*
* Push-pull primary halves: L_each = L_total/4 = 9.525H
* Secondary: L = L_pri_half / N_half² = 9.525 / 2.237² = 1.903H
* Tertiary: L = L_pri_half / (N_pri_half/N_tert)² = 9.525 / 11.1² = 0.077H
*
* B+ connects to center tap of primary (serves as plate load for 12AU7s).

* Center tap to B+ (low-R connection, transformer primary IS the plate load)
R_opt_ct vcc opt_ct 1m

* Push-pull primary halves
L_opt_a plate2a opt_ct 9.525
L_opt_b opt_ct plate2b 9.525

* Secondary (output)
L_opt_sec out 0 1.903

* Tertiary (overall negative feedback to 12AX7 cathode)
L_opt_fb 0 fb 0.077

* Coupling between all windings on the S-217-D core.
* Measured k ≈ 0.9998 (from L_leak=19mH, L_pri=38.1H) but k>0.95
* causes convergence failure in both ngspice and trapezoidal companion
* models for 3+ winding transformers. Using k=0.95, validated in ngspice.
K_opta L_opt_a L_opt_sec 0.95
K_optb L_opt_b L_opt_sec 0.95
K_optab L_opt_a L_opt_b 0.95
K_fba L_opt_a L_opt_fb 0.95
K_fbb L_opt_b L_opt_fb 0.95
K_fbsec L_opt_sec L_opt_fb 0.95

* Output load (high-impedance bridging, typical of modern equipment)
Rload out 0 100k

* === SWITCH DIRECTIVES ===
* HF Boost frequency: 7 positions (ganged C + L)
* Values computed from f_c, RATIO_L1_C1=12e6:
*   C1 = sqrt(1 / (RATIO * (2*pi*fc)^2)), L1 = RATIO * C1
* Positions: 3kHz, 4kHz, 5kHz, 8kHz, 10kHz, 12kHz, 16kHz
.switch C_hfb,L_hfb 15.3n/183.8m 11.5n/137.8m 9.19n/110.3m 5.74n/68.9m 4.59n/55.1m 3.83n/45.9m 2.87n/34.5m "HF Boost Freq"

* LF frequency: 4 positions (ganged boost cap C_lfb + atten cap C_lfa)
* C_lfa = C_lfb / 30 (LF atten cap tracks boost cap)
* Positions: 20Hz, 30Hz, 60Hz, 100Hz
.switch C_lfb,C_lfa 2.2u/73.3n 1.1u/36.7n 560n/18.7n 330n/11n "LF Freq"

* HF Cut frequency: 3 positions
* Positions: 5kHz, 10kHz, 20kHz
.switch C_hfc 270n 135n 68n "HF Cut Freq"

* === POTENTIOMETER DIRECTIVES ===
* HF Boost: 3-terminal 10k linear pot (upper + lower arms, link inversely)
.pot R_hfb_u 1 10k "HF Boost (upper)"
.pot R_hfb_l 1 10k "HF Boost (lower)"
* Bandwidth/Q: 2.5k linear pot (series with 390Ω offset resistor R_q_off)
.pot R_hfb_q 1 2.5k "Bandwidth"
* LF Boost: 10k audio pot (shunt from mid to ground)
.pot R_lfb 1 10k "LF Boost"
* LF Atten: 100k audio pot (parallel with LF atten cap)
.pot R_lfc 1 100k "LF Atten"
* HF Cut: 3-terminal 1k linear pot (upper + lower arms, link inversely)
.pot R_hfc_u 1 1k "HF Cut (upper)"
.pot R_hfc_l 1 1k "HF Cut (lower)"

.END
