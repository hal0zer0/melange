* Two-stage tube amp + transformer with NFB
* Tests whether M=4 (two tubes) with transformer feedback converges
*
* Stage 1: 12AX7 common-cathode, plate coupled to stage 2
* Stage 2: 12AX7 common-cathode, plate to transformer primary
* Feedback: transformer tertiary -> stage 1 cathode
*
.model 12AX7 TRIODE(MU=100 EX=1.4 KG1=1060 KP=600 KVB=300)

* Power supply
Vcc vcc 0 DC 250

* Input coupling
Cin in grid1 100n
Rg1 grid1 0 1Meg

* Stage 1
T1 grid1 plate1 cathode1 12AX7
Ra1 vcc plate1 100k
Rk1 cathode1 0 1.5k
Ck1 cathode1 0 25u

* Interstage coupling
Cc plate1 grid2 10n
Rg2 grid2 0 470k

* Stage 2
T2 grid2 plate2 cathode2 12AX7
Ra2 vcc plate2 100k
Rk2 cathode2 0 1.5k

* Output transformer (130H, k=0.99 — Pultec scale)
L_pri plate2 xfmr_ct 130
L_sec out 0 26
L_tert fb_n fb_p 13
K1 L_pri L_sec 0.99
K2 L_pri L_tert 0.99
K3 L_sec L_tert 0.99

* Transformer center tap to VCC (DC plate supply through winding)
Rct vcc xfmr_ct 100

* Feedback from tertiary to stage 1 cathode (series-voltage NFB)
Rfb fb_p cathode1 1k
Rfb_gnd fb_n 0 100

* Output load
Rload out 0 10k

* Stability caps
C1 plate1 0 100p
C2 plate2 0 100p
C3 out 0 100p
