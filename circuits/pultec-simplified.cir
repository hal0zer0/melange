* Pultec-simplified: four-tube circuit with passive EQ network
* Same as four-tube-two-xfmr-fb.cir but with the Pultec's exact EQ network
* and HS-29 winding topology
*
.model 12AX7 TRIODE(MU=100 EX=1.4 KG1=1060 KP=600 KVB=300)
.model 12AU7 TRIODE(MU=21.5 EX=1.3 KG1=1180 KP=84 KVB=300)

* Power supply
Vcc vcc 0 DC 290

* === PASSIVE EQ NETWORK (simplified: HF boost + LF path) ===
* HF boost: in → R_hfb_u → b → R_hfb_l → eq, with LC series from b
R_hfb_u in b 10k
R_hfb_l b eq 10k
C_hfb b c_hfb 15.3n
L_hfb c_hfb d_hfb 183.8m
R_hfb_q d_hfb eq 2.5k

* LF path: eq → h → R2 → out_tap → R3 → mid
C_lfa eq h 73.3n
R_lfc eq h 100k
R2 h out_tap 1k
R3 out_tap mid 10k
R_lfb mid 0 10k
C_lfb mid 0 2.2u

* HF cut: eq → f → mid
R_hfc_u eq f 1k
R_hfc_l f mid 1k
C_hfc f mid 270n

* === HS-29 INPUT TRANSFORMER (3-winding, 130H, center-tapped secondary) ===
L_int_pri out_tap 0 130
L_int_a grid1 hs29_ct 130
L_int_b hs29_ct fb_node 130
K_inta L_int_pri L_int_a 0.99
K_intb L_int_pri L_int_b 0.99
K_intab L_int_a L_int_b 0.98
R_ct hs29_ct 0 100

* === 12AX7 DUAL TRIODE (differential pair) ===
* Grid cross-coupling
C_gg grid1 mid_gg 270p
R_gg mid_gg grid2 43k

T1a grid1 plate1 cathode 12AX7
T1b grid2 plate2 cathode 12AX7
Ra1a vcc plate1 100k
Ra1b vcc plate2 100k
Rk cathode fb_node 820

* === 12AU7 PUSH-PULL OUTPUT ===
C_coup2a plate1 grid2a 250n
C_coup2b plate2 grid2b 250n

* Grid bias
Vbias v250 0 DC 250
R_bias_hi v250 bias_31v 470k
R_bias_lo bias_31v 0 62k
Rbias2a bias_31v grid2a 470k
Rbias2b bias_31v grid2b 470k

T2a grid2a plate2a cath2 12AU7
T2b grid2b plate2b cath2 12AU7
Ra2a vcc plate2a 100k
Ra2b vcc plate2b 100k
Rk2 cath2 0 4.7k

* Plate stoppers
R_stop2a plate2a opt_a 360
R_stop2b plate2b opt_b 360

* === S-217-D OUTPUT TRANSFORMER (4-winding) ===
L_opt_a opt_a opt_ct 9.525
L_opt_b opt_ct opt_b 9.525
L_opt_sec out 0 1.903
L_fb_a fb_s5 fb_s3 2.4
R_opt_ct vcc opt_ct 1m
K_opta L_opt_a L_opt_sec 0.95
K_optb L_opt_b L_opt_sec 0.95
K_optab L_opt_a L_opt_b 0.95
K_fba L_opt_a L_fb_a 0.95
K_fbb L_opt_b L_fb_a 0.95
K_sec_fb L_opt_sec L_fb_a 0.95

* === FEEDBACK ===
R_fb_shunt fb_s3 fb_s5 1000
R_fb_dcref fb_s5 0 1Meg
R_fb_a fb_s3 cathode 360
R_fb_b fb_s5 fb_node 360

* Output load
Rload out 0 100k

* Stability caps
C1a grid1 0 1n
C1b grid2 0 1n
C2a plate2a 0 100p
C2b plate2b 0 100p
C4 out 0 100p
