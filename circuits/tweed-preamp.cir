* Tweed Preamp — Fender-style Two-Stage 12AX7 Guitar Amp Sim
*
* Classic American guitar amp voicing. Two triode halves of a single 12AX7
* with interstage volume control and bright switch. Clean sparkle to mild
* breakup depending on input level and volume setting.
*
* Based on Fender 5F1 Champ / 5E3 Deluxe preamp topology.
* Component values from standard Fender schematics.
*
* Topology:
*   in -> Rin(68k) -> Cin(100n) -> grid1 -> [12AX7 T1] -> plate1 ->
*   Cc1(22n) -> vol_in -> [C_bright + R_mix(470k)] -> vol_out ->
*   R_vol(shunt) -> Cin2(22n) -> grid2 -> [12AX7 T2] -> plate2 ->
*   Rpad(390k) -> pad -> Cout(1u) -> out
*
* M=4 nonlinear (2 triodes x 2D each), N=13 nodes
* Controls: Volume (pot), Bright (3-pos switch)

.model 12AX7 TRIODE(MU=100 EX=1.4 KG1=1060 KP=600 KVB=300)

* B+ supply (standard 12AX7 plate voltage)
VCC vcc 0 DC 250

* === STAGE 1: Clean input gain ===
* Grid stopper (68k) + input coupling cap
Rin in rin_out 68k
Cin rin_out grid1 100n
* Grid leak resistor
Rg1 grid1 0 1Meg

* 12AX7 triode — stage 1 (grid, plate, cathode)
T1 grid1 plate1 cathode1 12AX7

* Plate load
Ra1 vcc plate1 100k
* Cathode bias with full bypass — max gain, "tweed" character
* Bias point: Vk ~ 1.5V, Ia ~ 1mA, Va ~ 150V
Rk1 cathode1 0 1.5k
Ck1 cathode1 0 25u

* === INTERSTAGE: Volume + Bright ===
* Coupling cap from plate1
Cc1 plate1 vol_in 22n

* Bright cap — bypasses R_mix at treble frequencies
C_bright vol_in vol_out 120p

* Series mixing resistor (models "top half" of volume pot)
R_mix vol_in vol_out 470k

* Volume shunt pot to ground
* Low R = signal bleeds to ground = quiet
* High R = signal stays = loud
* Range: ~54 dB attenuation at min to ~6 dB insertion loss at max
R_vol vol_out 0 500k
.pot R_vol 500 500k "Volume"

* === STAGE 2: Drive stage ===
* Coupling cap + grid leak
Cin2 vol_out grid2 22n
Rg2 grid2 0 1Meg

* 12AX7 triode — stage 2 (grid, plate, cathode)
T2 grid2 plate2 cathode2 12AX7

* Plate load
Ra2 vcc plate2 100k
* Partial cathode bypass — bass rolls off below ~156 Hz
* Tighter, more "blackface" voicing than fully bypassed
* f_c = 1 / (2*pi * 1.5k * 0.68u) ~ 156 Hz
Rk2 cathode2 0 1.5k
Ck2 cathode2 0 0.68u

* === OUTPUT PAD + COUPLING ===
* Resistive pad models output transformer attenuation
* Ratio: 6.8k / (390k + 6.8k) ~ 0.017 = -35 dB
Rpad plate2 pad 390k
Rshunt pad 0 6.8k
Cout pad out 1u
Rload out 0 100k

* === CONTROLS ===
* Bright switch: Off (1pF ~ nothing) / Normal (120pF) / Hot (470pF)
.switch C_bright 1p 120p 470p "Bright"

.END
