* Wurlitzer 200A Reed-Bar Preamp
* ================================
* Two-stage direct-coupled NPN CE amplifier (TR-1, TR-2 = 2N5089)
* with series-series emitter feedback through R-10/Ce1 and
* Miller feedback caps C-3, C-4.
*
* Topology resolved from BustedGear 200A schematic (874 KB PDF)
* at 1000-2000 DPI plus DC analysis and SPICE stability validation.
* All component values VERIFIED.
*
* TOPOLOGY NOTES:
*   R-2 (2M to +15V) and R-3 (470K to GND) are both at base1,
*   providing the DC bias: Vth=2.85V -> Vb=2.45V with base current loading.
*
*   FEEDBACK (CORRECTED Feb 2026):
*   R-10 (56K) feeds from preamp output to fb node.
*   Ce1 (4.7 MFD) AC-couples fb to TR-1's emitter.
*   This is SERIES-SERIES NEGATIVE FEEDBACK (emitter feedback).
*   Re1 (33K) provides the separate DC path from emitter to ground.
*
*   LG-1 (LDR) shunts fb to ground via cable Pin 1 ->
*   50K VIBRATO pot -> 18K -> LG-1 -> GND.
*   When LDR is LOW (bright): fb shunted to ground ->
*     feedback can't reach emitter -> HIGHER gain (~12 dB / 4.0x)
*   When LDR is HIGH (dark): full feedback reaches emitter ->
*     strong emitter degeneration -> LOWER gain (~6 dB / 2.0x)
*
*   IMPORTANT: An earlier version had R-10 feeding to node_A
*   (before .022uF coupling cap), forming shunt-feedback. That
*   topology is WRONG -- the two non-inverting CE stages create
*   POSITIVE feedback to node_A, causing oscillation. Emitter
*   feedback is inherently negative and SPICE-validated stable.
*
* DC operating points (targets):
*   TR-1: B=2.45V, E=1.95V, C=4.1V, Ic~73uA
*   TR-2: B=4.1V, E=3.4V, C=8.8V, Ic~3.4mA
*
* Closed-loop gain (SPICE-measured, corrected topology):
*   No tremolo (R_ldr=1M): 6.0 dB (2.0x)
*   Tremolo bright (R_ldr=19K): 12.1 dB (4.0x)
*   Tremolo boost: 6.1 dB (matches EP-Forum measurement)
*
* N=10 nodes: in, mid_in, base1, emit1, coll1, emit2a, emit2b, coll2, out, fb
* M=5 nonlinear dimensions: 2 BJTs (2D each) + 1 diode (1D)

* --- Input coupling: R1 (22K) in series with Cin (0.022uF) ---
* R1 is external to the original subcircuit (between pickup and preamp input).
* Modeled as two components with intermediate node mid_in to preserve
* the 22K series impedance and ~330 Hz highpass corner.
R1    in     mid_in  22K
Cpar  in     0       1P
Cin   mid_in base1   0.022U

* --- Base1 bias network ---
* R-2 (2M) from Vcc to base1 -- DC pull-up
* R-3 (470K) from base1 to ground -- DC pull-down
* Thevenin: Vth = 15 * 470K / (2M + 470K) = 2.854V
R2    vcc   base1  2MEG
R3    base1 0      470K

* --- Protection diode (reverse-biased under normal operation) ---
D1    0     base1  D1N4148

* --- Stage 1: TR-1 (2N5089 NPN common-emitter) ---
* Rc1 = 150K collector load
* Re1 = 33K DC emitter path to ground
* Ce1 = 4.7uF couples emitter to feedback node (NOT to ground!)
* C-3 = 100pF collector-base Miller feedback cap
Q1    coll1 base1 emit1  Q2N5089
Rc1   vcc   coll1  150K
Re1   emit1 0      33K
Ce1   emit1 fb     4.7U
Cc3   coll1 base1  100P

* --- Stage 2: TR-2 (2N5089 NPN common-emitter) ---
* Direct-coupled: TR-1 collector = TR-2 base (coll1 node)
* Rc2 = 1.8K collector load
* Re2a = 270 ohm (bypassed by Ce2 = 22uF) + Re2b = 820 ohm (unbypassed)
* C-4 = 100pF collector-base Miller feedback cap
Q2    coll2 coll1 emit2a  Q2N5089
Rc2   vcc   coll2  1.8K
Re2a  emit2a emit2b  270
Ce2   emit2a emit2b  22U
Re2b  emit2b 0    820
Cc4   coll2  coll1  100P

* --- Output series resistor ---
R9    coll2 out    6.8K

* --- Global AC negative feedback (series-series / emitter) ---
* R-10 (56K) from output to feedback node (fb).
* Ce1 (4.7 MFD) AC-couples fb to TR-1 emitter.
* LDR (external) shunts fb to ground, modulating
* how much feedback reaches the emitter and thus the gain.
R10   out   fb     56K

* --- Tremolo LDR (dynamic pot) ---
* For no tremolo: R_ldr = 1M (full feedback, low gain)
* For tremolo bright: R_ldr ~ 19K (shunted feedback, high gain)
R_ldr fb    0      100k
.pot R_ldr 1k 1Meg "Tremolo"

* --- Supply ---
V1    vcc   0      DC 15

* --- Device models ---
.model Q2N5089 NPN(IS=3.03e-14 BF=500)
.model D1N4148 D(IS=2.52e-9 N=1.752)
