Tube Screamer TS808
* Ibanez TS-808 overdrive — faithful clipping stage, simplified tone & volume
* Reference: ElectroSmash TS808 analysis, R.G. Keen "Technology of the Tube Screamer"
*
* This implementation: Copyright (c) 2026 Melange Contributors
* License: MIT OR Apache-2.0
*
* SIGNAL PATH:
*   Input → coupling cap → CLIPPING AMP (IC1a) → TONE → VOLUME → output
*
* CLIPPING STAGE (IC1a): Faithful to real TS808.
*   Non-inverting op-amp with antiparallel diodes in feedback.
*   Audio enters V+ (non-inverting). Feedback at V- with 51K+500K drive pot.
*   4.7K + 0.047uF ground impedance creates the famous mid-hump: bass below
*   ~720Hz sees high impedance, gain drops to unity, bass is NOT clipped.
*   Gain = 1 + R_drive / Z_gnd: 12x (21 dB) to 118x (41 dB).
*
* TONE: Simplified from real TS808 (which uses IC1b + R8/C6/20K pot).
*   The real tone section has a complex second-opamp active filter. Our model
*   captures the essential behavior: R_tone + C5 form a variable lowpass.
*   Low R_tone = bright (fc ~1.4kHz), high R_tone = dark (fc ~72Hz).
*   This matches the net frequency response; the active circuit just adds
*   an impedance buffer that melange's ideal nodes don't need.
*
* VOLUME: Simplified. Real TS808 uses a 100K audio-taper wiper pot (true
*   voltage divider). Melange pots are variable resistors, so we approximate
*   with a shunt-to-ground pot + fixed series resistor.
*
* Input/output buffers (BJT emitter followers in real TS808) are omitted —
* they are unity gain and melange's input conductance handles impedance.

* --- Input coupling ---
Cin in n1 0.047u
R_pull n1 0 1Meg

* === CLIPPING AMPLIFIER (IC1a) ===
* V+ = n1 (audio), V- = n_inv (feedback junction), out = n_clip
U1 n1 n_inv n_clip JRC4558

* Inverting input ground impedance (mid-hump HPF)
R4 n_inv n_gnd 4.7k
C3 n_gnd 0 0.047u

* Feedback path (all in parallel: output to inverting input)
R_drive n_clip n_inv 551k
D1 n_clip n_inv D1N4148
D2 n_inv n_clip D1N4148
C4 n_clip n_inv 51p

* === TONE CONTROL ===
* Variable lowpass: R_tone + C5. Cutoff = 1/(2*pi*R_tone*C5)
*   R_tone = 500:  fc = 1447 Hz (bright, treble passes)
*   R_tone = 5K:   fc = 145 Hz  (mid, balanced)
*   R_tone = 10K:  fc = 72 Hz   (dark, only bass passes)
R_tone n_clip n_tone 5k
C5 n_tone 0 0.22u

* === VOLUME CONTROL ===
* Series R + shunt pot. R_vol to ground controls output level.
*   R_vol = 100K: output = 100K/(10K+100K) = 91% (-0.8 dB)
*   R_vol = 10K:  output = 10K/(10K+10K)   = 50% (-6 dB)
*   R_vol = 500:  output = 500/(10K+500)    = 5%  (-26 dB)
R_vol_ser n_tone n_vol 10k
R_vol n_vol 0 100k

* === OUTPUT COUPLING ===
* 10uF: low enough for ~1.6Hz cutoff with 1Meg load (no bass loss)
C_out n_vol out 10u
R_out out 0 1Meg

* --- Models ---
.model D1N4148 D(IS=2.52e-9 RS=0.568 N=1.752)
.model JRC4558 OA(AOL=200000 ROUT=75)

* --- Controls ---
.pot R_drive 51k 551k "Drive"
.pot R_tone 500 10k "Tone"
.pot R_vol 500 100k "Volume"

.END
