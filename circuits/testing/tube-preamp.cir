* 12AX7 Tube Preamp
* Copyright (c) 2026 Melange Contributors
* License: MIT OR Apache-2.0
*
* Classic common-cathode triode gain stage inspired by the
* Pultec EQP-1A makeup gain amplifier. 12AX7 (ECC83) high-mu
* twin triode with passive RC tone control and output pad.
*
* The real Pultec follows the 12AX7 with a 12AU7 cathode follower
* and output transformer that attenuate the plate signal back to
* line level. We model that with a resistive pad (Rpad + Rshunt)
* giving ~36dB attenuation — net circuit gain near unity.
*
* Topology:
*   in -> Cin -> grid -> [12AX7] -> plate -> Rt -> tone -> Rpad -> pad -> Cout -> out
*   Plate load Ra to B+ (250V), cathode bias Rk bypassed by Ck.
*   Output pad models transformer + cathode follower attenuation.
*
* At unity input: clean tube coloration with 2nd/3rd harmonics.
* Above ~3V input: soft asymmetric clipping (classic tube saturation).

.model 12AX7 TRIODE(MU=100 EX=1.4 KG1=1060 KP=600 KVB=300)

* B+ power supply (250V plate voltage)
VCC vcc 0 DC 250

* Input coupling cap (f_low = 1/(2pi * 1M * 100n) = 1.6 Hz)
Cin in grid 100n

* Grid leak resistor (DC bias to ground)
Rg grid 0 1Meg

* 12AX7 triode (grid, plate, cathode)
T1 grid plate cathode 12AX7

* Plate load resistor
Ra vcc plate 100k

* Cathode bias with bypass cap
* Rk sets quiescent Ip ~ 0.8mA, Vgk ~ -1.2V
* Ck fully bypasses Rk above ~4 Hz for maximum gain
Rk cathode 0 1.5k
Ck cathode 0 25u

* Passive tone control (RC low-pass after gain stage)
* f_cut = 1/(2pi * 47k * 1n) ~ 3.4 kHz (warm rolloff)
Rt plate tone 47k
Ct tone 0 1n

* Output pad (models Pultec cathode follower + output transformer)
* Atten = Rshunt / (Rt + Rpad + Rshunt) ~ 1/65 (-36dB)
* Net gain: 60x tube * 1/65 pad ~ 0.9x (near unity)
Rpad tone pad 390k
Rshunt pad 0 6.8k

* Output coupling (f_low = 1/(2pi * 6.4k * 1u) ~ 25 Hz)
Cout pad out 1u
Rload out 0 100k

* Dynamic potentiometers (for compiled plugin)
* Tone: 10k (bright, ~16kHz) to 100k (dark, ~1.6kHz)
.pot Rt 10k 100k
* Character: 47k (slightly less gain) to 220k (more gain + harmonics)
.pot Ra 47k 220k

.END
