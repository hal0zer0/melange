* EL84 Single-Stage Class A Power Amp
* Copyright (c) 2026 Melange Contributors
* License: MIT OR Apache-2.0
*
* Minimal single-tube EL84 Class A power amplifier for pentode
* smoke-testing. One EL84 pentode in common-cathode, fixed screen
* supply, cathode bias, resistive plate load. No output transformer
* (the plate RL models the OT primary impedance).
*
* Topology:
*   in -> Cin -> grid -> [EL84] -> plate -> out
*                         |        |
*                         cath     RL -> B+
*                         |
*                        Rk (cathode bias)
*
*   Screen grid tied to a fixed +300V supply through Rg2=1k.
*
* Exercises the new SharpPentode codepath end-to-end: parser,
* MNA stamping (N_v/N_i 3 rows each), DC-OP convergence to a
* Class A bias point (Vpk ~ 250V, Vg2k ~ 290V, Vgk ~ -7V, Ip ~ 40mA),
* codegen template emission, and per-sample NR stability.
*
* This is a PHASE 1A validation circuit. It is NOT a realistic amp —
* no output transformer, no feedback. For a full AC15-style validation
* use ac15.cir.

* Reefman Derk §4.4 EL84 fit (TubeLib.inc 2016-01-23)
.model EL84 VP(MU=23.36 EX=1.138 KG1=117.4 KG2=1275 KP=152.4 KVB=4015.8
+              ALPHA_S=7.66 A_FACTOR=4.344e-4 BETA_FACTOR=0.148
+              IG_MAX=8m VGK_ONSET=0.7)

* B+ plate supply (300V)
VCC plate_supply 0 DC 300

* Screen supply (300V — in a real amp this would come off the same B+
* bus, but we use an ideal supply here to simplify the DC-OP topology)
VSCR screen_supply 0 DC 300

* Input coupling (f_low = 1/(2pi * 470k * 10n) ~ 34 Hz)
Cin in grid 10n

* Grid leak (DC bias to ground)
Rg grid 0 470k

* EL84 pentode: plate-grid-cathode-screen ordering
P1 plate grid cath screen EL84

* Plate load resistor (5k6 ~ typical OT primary impedance for EL84)
Ra plate_supply plate 5.6k

* Screen stop resistor (prevents runaway under clip)
Rg2 screen_supply screen 1k

* Cathode bias (Rk=130 sets ~-7V grid bias at ~40mA plate current)
* Unbypassed — simpler DC-OP, some local NFB
Rk cath 0 130

* Output tap directly from plate (no coupling cap — keeps test simple)
* In a real amp the plate would drive an OT primary, then coupling cap
Rout plate out 1Meg

.END
