* Marshall Plexi-class Mockup (100W, 4×EL34)
* Copyright (c) 2026 Melange Contributors
* License: MIT OR Apache-2.0
*
* Phase 1b validation target — demonstrates the pentode grid-off
* reduction on a realistic "big amp" topology. This is NOT a precise
* Marshall JCM800 / Super Lead clone, just a structurally representative
* 100W-class amp that exercises the M-cap problem that phase 1b is
* designed to solve.
*
* The purpose of this circuit:
*
*   - Without grid-off: 4×EL34 (3D) + 3×12AX7 (2D) = 18 dims > 16 DK cap
*     → routes to nodal full-LU (~50-100× RT on this topology)
*
*   - With grid-off (phase 1b default, --tube-grid-fa auto):
*     4×EL34 (2D) + 3×12AX7 (2D) = 14 dims < 16 DK cap
*     → routes to DK Schur (Gaussian elim at M=14, ~5-10× faster than nodal)
*
* Both paths must produce DC-OP convergence with zero NR failures, and
* output signals that agree to floating-point precision (the Vg2k
* freezing approximation introduces <1% error for amps with heavily
* bypassed screens, which this circuit has via 47 µF screen caps).
*
* Topology:
*
*   VIN → Cin → Rg1 → [12AX7 V1]
*                       ↓ Cc1
*                      pi1_in → [12AX7 V2]
*                                 ↓ Cc2
*                                pi2_in → [12AX7 cathodyne PI]
*                                            ↓ Cc_p           ↓ Cc_k
*                                         el1_g/el3_g       el2_g/el4_g
*                                            ↓                ↓
*                                      [EL34 ×2]         [EL34 ×2]
*                                      (parallel pair)   (parallel pair)
*                                            ↓                ↓
*                                         pa_1              pa_2
*                                            └──── OT ───────┘
*                                                    ↓
*                                                  8 Ω load
*
* Target bias points:
*   V1, V2 (12AX7):  Vgk ≈ -1.5 V, Vpk ≈ 200 V, Ip ≈ 0.9 mA each
*   V3 PI (12AX7):   Vgk ≈ -3 V,   Vpk ≈ 260 V, Ip ≈ 0.8 mA
*   EL34 ×4:         Vgk ≈ -35 V,  Vpk ≈ 450 V, Vg2 ≈ 415 V, Ip ≈ 40 mA each
*   Shared cathode bias: 4 × 40 mA = 160 mA, Rk_pp ≈ 200 Ω, drops ~32 V.
*
* Real Marshall Super Lead runs 560 V B+ and ~540 V plate idle, producing
* 100 W into 8 Ω. My 480 V B+ is a safer starting point for a validation
* circuit; math should still exercise the grid-off reduction.

* -------------- Models --------------
.model 12AX7 TRIODE(MU=100 EX=1.4 KG1=3000 KP=600 KVB=300)

* EL34 — Reefman Derk §4.4 fit from TubeLib.inc (phase 1a.1)
.model EL34-P VP()

* -------------- Supplies --------------
VCC vcc 0 DC 480

* -------------- V1: 12AX7 input stage --------------
Cin     in     v1_g   22n
Rg_v1   v1_g   0      1Meg

T_v1    v1_g   v1_p   v1_k   12AX7

Ra_v1   vcc    v1_p   100k
Rk_v1   v1_k   0      1.5k
Ck_v1   v1_k   0      25u

* -------------- Interstage V1 → V2 --------------
Cc1     v1_p   v2_g   22n
Rg_v2   v2_g   0      1Meg

* -------------- V2: 12AX7 second gain stage --------------
T_v2    v2_g   v2_p   v2_k   12AX7

Ra_v2   vcc    v2_p   100k
Rk_v2   v2_k   0      1.5k
Ck_v2   v2_k   0      25u

* -------------- Interstage V2 → PI --------------
Cc2     v2_p   pi_in  22n
Rg_pi   pi_in  0      1Meg

* -------------- V3: 12AX7 cathodyne phase inverter --------------
T_pi    pi_in  pi_p   pi_k   12AX7

Ra_pi   vcc    pi_p   100k
Rk_pi   pi_k   0      100k

* -------------- PI → 4×EL34 push-pull drive --------------
* Cathodyne plate output drives el1_g and el3_g (same phase).
* Cathodyne cathode output drives el2_g and el4_g (opposite phase).
* Each EL34 has its own grid-leak resistor.
Cc_p1   pi_p   el1_g  22n
Cc_p2   pi_p   el3_g  22n
Cc_k1   pi_k   el2_g  22n
Cc_k2   pi_k   el4_g  22n

Rg_e1   el1_g  0      220k
Rg_e2   el2_g  0      220k
Rg_e3   el3_g  0      220k
Rg_e4   el4_g  0      220k

* -------------- 4×EL34 push-pull output stage --------------
* Four EL34s in parallel pairs. Two tubes drive each OT primary half.
* All four share a common cathode bias (phase 1b: all four should
* qualify for grid-off reduction simultaneously under DC-OP detection).
P_e1    pa_1   el1_g  ck_pp  sc_pp  EL34-P
P_e2    pa_2   el2_g  ck_pp  sc_pp  EL34-P
P_e3    pa_1   el3_g  ck_pp  sc_pp  EL34-P
P_e4    pa_2   el4_g  ck_pp  sc_pp  EL34-P

* Shared screen bus: 1k dropping resistor from B+, 47u bypass
* (heavy bypass makes Vg2k nearly constant — the exact condition
*  that justifies phase 1b's Vg2k freezing approximation)
Rg2_pp  vcc    sc_pp  1k
Cg2_pp  sc_pp  0      47u

* Shared cathode bias (~200 Ω drops ~32 V at 160 mA total)
Rk_pp   ck_pp  0      200
Ck_pp   ck_pp  0      100u

* -------------- Output Transformer (Marshall-style 100W) --------------
* Zpri ≈ 1.7 kΩ plate-to-plate for 4×EL34 in parallel pairs.
* L_pri total ≈ 80 H, split 50/50 at center tap → 40 H per half.
* Wait: halving reflects Zpri, so L_pri_half should be L_pri_total / 4 = 20 H.
* Np/Ns = sqrt(1700 / 8) ≈ 14.6.
* L_sec = L_pri_half × (Ns/Np)² = 20 × (1/14.6)² ≈ 0.094 H (94 mH).
* DCR: ~150 Ω per primary half (Marshall OTs are thicker wire than KT88),
* ~0.3 Ω secondary.

* Center tap to B+ — primary IS the plate load
R_opt_ct   vcc    ot_ct   1m

* Push-pull primary halves through winding DCR
R_dcr_a    pa_1   pa_1_w  150
R_dcr_b    pa_2   pa_2_w  150
L_pri_a    pa_1_w ot_ct   20
L_pri_b    ot_ct  pa_2_w  20

* Secondary through winding DCR, returned to ground
R_dcr_sec  out_w  out     0.3
L_sec      out_w  0       94m

* 8 Ω speaker load
Rload      out    0       8

* Primary halves mutually coupled + both coupled to secondary
K_a_sec    L_pri_a L_sec   0.9999
K_b_sec    L_pri_b L_sec   0.9999
K_a_b      L_pri_a L_pri_b 0.9999

.END
