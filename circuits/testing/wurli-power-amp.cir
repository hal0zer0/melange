* Wurlitzer 200A Power Amplifier
* ===============================
* Quasi-complementary Class AB push-pull, ~20W into 8 ohms.
* Topology from verified 200A schematic (#203720-S-3).
* Transistor models: full Gummel-Poon from SPICE validation library.
*
* Signal chain:
*   PNP diff pair (TR-7/TR-8) -> NPN VAS (TR-14) ->
*   Vbe multiplier (TR-9) -> Sziklai output pairs
*
* Key topology points (traced from schematic Feb 2026):
*   - R-29 (1K) is TR-7 collector load to -Vcc (NOT VAS emitter degen)
*   - TR-14 emitter directly on -Vcc rail (no degeneration)
*   - R-32/R-33 (1.8K each) form bootstrapped VAS collector load
*   - C-12 (100u) bootstraps from mid-point of R32/R33 to output
*   - C-11 (100pF) Miller comp: VAS collector to VAS base
*   - Output stage: Sziklai/CFP pairs (TR-10/TR-11, TR-12/TR-13)
*   - Output tapped between emitter resistors R-37 and R-38
*
* No variable elements (no pots). Volume pot is upstream.

* --- Input coupling ---
C8    in     in_ac   4.7U
C9    in_ac  0       1N
Cpar  in     0       1P

* --- Input bias ---
* R-27 (15K): input bias resistor, TR-7 base to ground.
R27   in_ac  0       15K

* --- Differential pair (TR-7, TR-8: PNP 2N5087) ---
* R-28 (10K): tail current source for diff pair (emitters to +Vcc).
* Schematic note: "select R28 for 0V DC at point [16]"
R28   emit_pair  vp    10K
Q7    coll7    in_ac     emit_pair   Q2N5087
Q8    coll8    fb_inv    emit_pair   Q2N5087

* --- Collector loads to -Vcc rail ---
* R-29 (1K): TR-7 collector load to -Vcc. Single-ended output diff pair:
*   only coll7 drives VAS. TR-8 collector goes directly to -Vcc rail
*   (traced to -22.5V node in power supply section, no separate load).
R29      coll7   vn    1K
R_coll8  coll8   vn    1m

* --- Negative feedback network ---
* R-31 (15K) from output to inverting input of diff pair.
* R-30 + C-10 in series: sets AC gain = 1 + R31/R30 = 69x (37 dB)
* At DC: C-10 open -> 100% feedback -> output locked to ~0V
* Corner freq = 1/(2*pi*220*22u) = 33 Hz
R31   out     fb_inv   15K
R30   fb_inv  c10_node 220
C10   c10_node 0       22U

* --- VAS / pre-driver (TR-14: NPN MPSA06) ---
* Base = coll7 (-22V), emitter = -Vcc (-22.5V), Vbe ~= 0.5V.
* Feedback adjusts diff pair balance to set correct VAS current.
* Q14 collector = drv_bot (below Vbe multiplier). VAS sinks current
* from drv_bot, pulling it to -0.65V.
* Current chain: load -> vas_out -> Q9 -> drv_bot -> Q14 -> -Vcc
Q14   drv_bot   coll7    vn   QMPSA06

* --- Miller compensation: VAS collector to VAS base ---
C11   drv_bot   coll7   100P

* --- Bootstrapped VAS collector load ---
* +Vcc -> R-32 (1.8K) -> boot -> R-33 (1.8K) -> vas_out
* C-12 bootstraps boot node to output for high AC impedance.
R32   vp     boot      1.8K
R33   boot   vas_out   1.8K
C12   boot   out       100U

* --- Vbe multiplier / bias control (TR-9: NPN MPSA06) ---
* Sets ~1.1V drop between vas_out and drv_bot for class AB bias.
* Vce = Vbe * (1 + R34/R35) = ~0.65 * 1.73 = ~1.12V
Q9    vas_out   bias_mid   drv_bot   QMPSA06
R34   vas_out   bias_mid   160
R35   bias_mid  drv_bot    220

* --- Top Sziklai: TR-10 (NPN driver) + TR-11 (PNP output TIP36C) ---
* TR-10: B=vas_out, C=base11, E=nodeC
* TR-11: E=+Vcc, B=base11 (from TR-10 C), C=nodeC
Q10   base11   vas_out   nodeC    QMPSA06
Q11   nodeC    base11    vp       QTIP36C
R36   base11   vp        270

* --- Bottom Sziklai: TR-12 (PNP driver) + TR-13 (NPN output TIP35C) ---
* TR-12: B=drv_bot, C=base13, E=nodeD
* TR-13: E=-Vcc, B=base13 (from TR-12 C), C=nodeD
Q12   base13   drv_bot   nodeD    QMPSA56
Q13   nodeD    base13    vn       QTIP35C
R39   base13   vn        270

* --- Output emitter resistors ---
* nodeC -> R37 -> output -> R38 -> nodeD
* (Fuses F-1 and F-2 omitted in simulation)
R37   nodeC   out   0.47
R38   nodeD   out   0.47

* --- Speaker load (8 ohm = two 16-ohm in parallel) ---
R_load out   0   8

* --- Supply ---
V1    vp   0   DC 22.5
V2    0    vn  DC 22.5

* --- Device models (full Gummel-Poon from SPICE validation) ---

.model Q2N5087 PNP(IS=3.18e-14 BF=254.8 NF=1.003 VAF=115
+ IKF=0.01 ISE=5.32e-15 NE=1.34 BR=3.56 NR=1.005 VAR=26
+ IKR=0.01 ISC=1.7e-13 NC=1.214 RB=120 RE=0.5 RC=2
+ CJE=3.33e-12 VJE=0.65 MJE=0.33 CJC=1.66e-12 VJC=0.4 MJC=0.33
+ TF=7.2e-10 TR=1e-7 XTB=1.4 EG=1.11 XTI=3)

.model QMPSA06 NPN(IS=1.5e-14 BF=200 NF=1 VAF=100
+ IKF=0.2 ISE=5e-13 NE=1.5 BR=4 NR=1 VAR=20
+ IKR=0.1 RB=10 RE=0.3 RC=0.5
+ CJE=10e-12 VJE=0.7 MJE=0.33 CJC=6e-12 VJC=0.5 MJC=0.33
+ TF=3.5e-10 TR=1e-7 XTB=1.5 EG=1.11 XTI=3)

.model QMPSA56 PNP(IS=1.5e-14 BF=200 NF=1 VAF=100
+ IKF=0.2 ISE=5e-13 NE=1.5 BR=4 NR=1 VAR=20
+ IKR=0.1 RB=10 RE=0.3 RC=0.5
+ CJE=10e-12 VJE=0.7 MJE=0.33 CJC=6e-12 VJC=0.5 MJC=0.33
+ TF=3.5e-10 TR=1e-7 XTB=1.5 EG=1.11 XTI=3)

.model QTIP35C NPN(IS=5e-12 BF=60 NF=1 VAF=80
+ IKF=5 ISE=3e-10 NE=1.8 BR=5 NR=1 VAR=20
+ IKR=1 RB=0.5 RE=0.02 RC=0.05
+ CJE=200e-12 VJE=0.7 MJE=0.33 CJC=150e-12 VJC=0.5 MJC=0.33
+ TF=2e-8 TR=5e-7 XTB=1.5 EG=1.11 XTI=3)

.model QTIP36C PNP(IS=5e-12 BF=40 NF=1 VAF=60
+ IKF=5 ISE=3e-10 NE=1.8 BR=4 NR=1 VAR=20
+ IKR=1 RB=0.5 RE=0.02 RC=0.05
+ CJE=200e-12 VJE=0.7 MJE=0.33 CJC=180e-12 VJC=0.5 MJC=0.33
+ TF=2.5e-8 TR=5e-7 XTB=1.5 EG=1.11 XTI=3)

.linearize Q9
