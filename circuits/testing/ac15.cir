* Vox AC15 (EF86 channel, simplified)
* Copyright (c) 2026 Melange Contributors
* License: MIT OR Apache-2.0
*
* Vox AC15 TB1-based single-channel (EF86 preamp → 12AX7 cathodyne
* phase inverter → 2× EL84 push-pull, cathode-biased Class A).
*
* Phase 1a validation target for melange pentode support. Exercises:
*   - EF86 pentode preamp (SharpPentode, EF86 catalog entry)
*   - 12AX7 cathodyne phase splitter (existing SharpTriode path)
*   - 2× EL84 pentodes in push-pull Class A (SharpPentode, EL84-P)
*
* Simplifications for phase 1e (to be lifted in later phases):
*   - Output transformer modelled with the Pultec-style coupled-inductor
*     topology: L_pri_a + L_pri_b + L_sec with all three K couplings at
*     0.9999, plus explicit R_dcr_* winding resistance and R_opt_ct
*     center-tap-to-B+ connection. Primary: 60H total (15H per half);
*     secondary: 15 mH for 8Ω tap (Np/Ns ≈ 31.6 from Zpri ≈ 8 kΩ PP).
*   - Output signal is taken from the transformer secondary across the
*     8Ω speaker load — realistic output levels in the +20 dBv range.
*   - No tone stack (cut + bass + treble). Keeps DC-OP path minimal.
*   - No NFB loop from OT secondary (AC15 TB1 has 22k NFB, small effect).
*
* Topology:
*   VIN → Cin → Rg1 → [EF86] → pa_ef → Cc1 → Rg2 → [12AX7 cathodyne]
*                                                        |    |
*                                                     p-out  k-out
*                                                        |    |
*                                                     Cc_p  Cc_k
*                                                        |    |
*                                                      g_e1  g_e2
*                                                        |    |
*                                                   [EL84 #1][EL84 #2]
*                                                        |    |
*                                                      pa_1  pa_2  -> out (pa_1)
*
* Target bias points (from Vox AC15 schematic, ±20%):
*   EF86:   Vgk ≈ -1.5V, Vpk ≈ 120V,  Ip ≈ 0.8 mA
*   12AX7:  Vgk ≈ -2V,   Vpk ≈ 150V,  Ip ≈ 0.6 mA
*   EL84:   Vgk ≈ -7V,   Vpk ≈ 280V,  Ip ≈ 36 mA (per tube)
*   Cathode bias resistor Rk_pp drops ~7V at 72 mA total → ~100Ω
*
* Gain at 1 kHz small-signal: ~40–50 dB (EF86 Av~100 · 12AX7 Av~30 · EL84)

* -------------- Models --------------
* 12AX7 — existing Koren triode fit
.model 12AX7 TRIODE(MU=100 EX=1.4 KG1=3000 KP=600 KVB=300)

* EF86 — Reefman Derk §4.4 fit from TubeLib.inc (2016-01-23)
.model EF86 VP(MU=40.8 EX=1.327 KG1=675.8 KG2=4089.6 KP=350.7 KVB=1886.8
+              ALPHA_S=4.24 A_FACTOR=5.95e-5 BETA_FACTOR=0.28
+              IG_MAX=4m VGK_ONSET=0.5)

* EL84 — Reefman Derk §4.4 fit from TubeLib.inc (2016-01-23)
.model EL84-P VP(MU=23.36 EX=1.138 KG1=117.4 KG2=1275 KP=152.4 KVB=4015.8
+                ALPHA_S=7.66 A_FACTOR=4.344e-4 BETA_FACTOR=0.148
+                IG_MAX=8m VGK_ONSET=0.7)

* -------------- Supplies --------------
* B+ rail (typical AC15: 310–330V after rectifier sag)
VCC vcc 0 DC 320

* -------------- EF86 preamp stage --------------
* Input coupling + grid leak
Cin    in    ef_g   22n
Rg_ef  ef_g  0      1Meg

* EF86 pentode (plate-grid-cathode-screen)
P_ef   pa_ef ef_g   ck_ef  sc_ef  EF86

* Plate load (220k per AC15 EF86 channel)
Ra_ef  vcc   pa_ef  220k

* Screen resistor (decoupled from plate rail)
Rg2_ef vcc   sc_ef  1Meg
Cg2_ef sc_ef 0      100n

* Cathode bias (Rk=820 with 25uF bypass, self-bias for -1.5V Vgk)
Rk_ef  ck_ef 0      820
Ck_ef  ck_ef 0      25u

* -------------- Interstage coupling --------------
Cc1    pa_ef pi_in  22n
Rg_pi  pi_in 0      1Meg

* -------------- 12AX7 Cathodyne Phase Inverter --------------
* Single triode with equal plate and cathode resistors (100k each).
* Plate output = -Vgrid_ac * Av/2, cathode output = +Vgrid_ac * Av/2.
* Inherently balanced (unlike long-tail pair).
T_pi   pi_in  pi_p  pi_k  12AX7

* Balanced loads: Ra = Rk = 100k
Ra_pi  vcc   pi_p   100k
Rk_pi  pi_k  0      100k

* -------------- PI → EL84 PP drive --------------
Cc_p   pi_p  el1_g  22n
Cc_k   pi_k  el2_g  22n

* Grid leaks
Rg_e1  el1_g 0      470k
Rg_e2  el2_g 0      470k

* -------------- EL84 push-pull output stage --------------
* Both EL84s share a common cathode resistor (cathode-biased PP).
* Shared screen grid node fed from B+ via single dropping resistor.

P_e1   pa_1  el1_g  ck_pp  sc_pp  EL84-P
P_e2   pa_2  el2_g  ck_pp  sc_pp  EL84-P

* Shared screen bus with 1k stop resistor from B+
Rg2_pp vcc    sc_pp  1k
Cg2_pp sc_pp  0      47u

* Shared cathode bias: ~100Ω drops 7V at 70 mA total (EL84 pair Class A)
Rk_pp  ck_pp  0      100
Ck_pp  ck_pp  0      100u

* -------------- Output Transformer (Woden/Drake-style) --------------
* Vox AC15 OT: push-pull EL84 → 8Ω speaker tap.
* Zpri ≈ 8 kΩ plate-to-plate (standard EL84 PP Class A load line).
* L_pri total ≈ 60 H, split 50/50 at center tap → 15 H per half.
* Np/Ns = sqrt(Zpri / Zsec) = sqrt(8000 / 8) ≈ 31.6.
* L_sec = L_pri_half × (Ns/Np)² = 15 × (1/31.6)² ≈ 0.015 H (15 mH).
* DCR: ~400 Ω per primary half (thin EL84 primary wire), 0.5 Ω secondary.
* K = 0.9999 (negligible leakage). Augmented-MNA solver handles K > 0.95
* cleanly via the augmented branch-current formulation (Pultec precedent,
* memory note: nodal_solver_augmented_mna.md).

* Center tap to B+ — primary is the plate load, no additional R needed.
R_opt_ct   vcc    ot_ct  1m

* Push-pull primary halves through winding DCR
R_dcr_a    pa_1   pa_1_w  400
R_dcr_b    pa_2   pa_2_w  400
L_pri_a    pa_1_w ot_ct  15
L_pri_b    ot_ct  pa_2_w 15

* Secondary through winding DCR, returned to ground
R_dcr_sec  out_w  out    0.5
L_sec      out_w  0      15m

* Speaker load (8 Ω tap)
Rload      out    0      8

* Coupling coefficients: primary halves to each other and to secondary.
* Three K directives, all at 0.9999 (Pultec precedent for high-Q OTs).
K_a_sec    L_pri_a L_sec   0.9999
K_b_sec    L_pri_b L_sec   0.9999
K_a_b      L_pri_a L_pri_b 0.9999

.END
