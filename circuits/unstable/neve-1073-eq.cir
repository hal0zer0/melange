* Neve 1073 EQ Section — B205 Balanced Bridge + HPF + BA284 §2
* From Neve drawings: B182 (HPF), B205 (LF/HF passive bridge),
* BA284 §2 (EQ amplifier), EH10023 (mainboard).
*
* B205 Topology (from Schemer trace, 2026-04-01):
*   Pin F = Pin H (connected on mainboard, driven by preamp)
*   F → 620Ω → node_L ←coupled_winding→ node_R ← 620Ω ← H
*   node_L → T1295_left → left_bot (Pin K) → R45(12K) → GND
*   node_R → T1295_right → right_bot (Pin M) → BA284 §2 input
*   left_bot → 12K → center_bot → 10nF → right_bot (bridge)
*   Caps: left_bot → C_left → pot_wiper ← C_right ← right_bot
*   Pot wiper to ground. Pot asymmetry unbalances bridge → EQ.
*
* KEY: T1295 windings use OPPOSING coupling (K=0.99, L_lf_r reversed)
*   so common-mode signal sees L-M ≈ 0.03H (passes through easily).
*   Without opposing coupling, common-mode sees L+M ≈ 6H → massive
*   HF attenuation that destroys the passband.
*
* Boost = LEFT cap grounded (left_bot shunted at EQ freq → right_bot
*   maintains signal → amp sees higher level at EQ freq → shelf boost).
* Cut = RIGHT cap grounded (right_bot shunted → amp sees less → cut).

* ============================================================
* SECTION 1: HPF (Board B182)
* 3rd-order C-L-C pi-section, 18 dB/oct
* ============================================================

R_source in     hp_in   600
C_hp1  hp_in   hp_mid  220N
R_hdamp hp_mid  0      10K
R_hdcr hp_mid  hp_l    490
L_hp   hp_l    0       3
C_hp2  hp_mid  hpf_out 220N
R_hterm hpf_out 0      5.1K

.switch C_hp1,C_hp2,L_hp,R_hdcr 1U/1U/10/1000 470N/470N/7/800 220N/220N/3/490 100N/100N/1.3/310 "HPF Freq"

* ============================================================
* SECTION 2: LF/HF Bridge (Board B205 + mainboard)
* Balanced Wheatstone bridge with coupled T1295 inductors.
* ============================================================

* --- Preamp output drives both sides of bridge ---
* Pin F = Pin H on mainboard (connected). R39(39K) shunt to ground.
R39    hpf_out  0       39K
R_lf620 hpf_out node_l  620
R_rf620 hpf_out node_r  620

* --- HF path: 22nF from top nodes to HF pins ---
C_hfp  node_l   hf_p    22N
C_hfn  node_r   hf_n    22N
* 15nF at center tap (Pin J)
C_hfj  node_l   node_r  15N

* --- HF pot (RV1, 10K) between P and N ---
* Controls HF balance. R37(1K2) to amp.
R_hf_pa hf_p    hf_wiper 5K
R_hf_pb hf_wiper hf_n   5K
R37     hf_wiper 0       1.2K

* --- T1295 coupled inductors (left and right halves) ---
* Same core, K=0.99. OPPOSING coupling: L_lf_r nodes reversed.
* Each side uses the same tap (3H default for 110 Hz).
R_ldcr_l node_l  lfl_ind  245
L_lf_l   lfl_ind left_bot 3
R_ldcr_r node_r  lfr_ind  245
L_lf_r   right_bot lfr_ind 3
K1 L_lf_l L_lf_r 0.99

* --- Bottom bus bridge (12K + 10nF between left and right) ---
R_12k  left_bot  center_bot  12K
C_10n  center_bot right_bot  10N

* --- Center reference: Pin K = left_bot, grounded through R45(12K) ---
R45    left_bot  0       12K

* --- LF switched caps (symmetric: same value on both sides) ---
* Switch selects frequency: 35/60/110/220 Hz
* Caps: 100nF/100nF/47nF/15nF (matched left-right at each position)
C_lf_l left_bot  pot_l   47N
C_lf_r right_bot pot_r   47N

* --- LF pot (RV2, 50K) as complementary pair to ground ---
* Wiper to ground. Asymmetry unbalances bridge.
* Full boost: pot_l=1 (left cap grounded), pot_r=50K (right cap open)
* Flat: pot_l=pot_r=25K (symmetric)
* Full cut: pot_l=50K, pot_r=1 (right cap grounded)
R_lfpot_l pot_l  0       1
R_lfpot_r pot_r  0       50K

* ============================================================
* SECTION 3: BA284 §2 EQ Amplifier (forward gain stage)
* ============================================================
* Inverting amp with input coupling R15(27K), feedback R17(120K).
* Gain = -R17/R15 = -120K/27K = -4.44 (13 dB).
* Bridge output (right_bot) → R15 → amp_inv (virtual ground).
* Amp input is ISOLATED from bridge output (no feedback to right_bot).
* R17 value corrected from 180K to 120K per BA284 schematic EX/10,284.
.model AMP2 OA(AOL=5000 ROUT=100)
U1    eq_ref  amp_inv  eq_out  AMP2
R_eqref eq_ref 0         1K
R15    right_bot amp_inv  27K
R17    eq_out  amp_inv   120K

* --- §2 output coupling ---
R57    eq_out   out      120
R_load out      0        5.1K

* --- Supply ---
VCC    vcc      0        DC 24

* --- LF frequency: fixed at 110 Hz (3H tap, 47nF caps) ---
* TODO: switch coupled inductors not yet supported in melange

.END
