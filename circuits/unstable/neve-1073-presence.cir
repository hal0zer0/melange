* Neve 1073 Presence EQ — Discrete BA284 Section 3 Amplifier
* Source: Neve drawing EX/10,284 Rev C. Parts list from 1073-fullpak.
*
* TOPOLOGY: CE (TR7) → EF (TR8) → EF (TR9) = 1 INVERSION = INVERTING
*
*   TR8 collector goes DIRECTLY to Vcc (no load resistor!) — confirmed
*   by user schematic trace 2026-04-02. TR8 is an emitter follower,
*   NOT a common-emitter stage. This means:
*   - Only 1 CE stage (TR7) provides voltage gain
*   - Forward path has 1 inversion (inverting output)
*   - R24(39K) from TR9 emitter area to base7 = NEGATIVE feedback ✓
*   - C15(100µF) at emit7→ground raises open-loop gain without oscillation
*
* User-traced topology (2026-04-02):
*   R25(27K):  Vcc(L) → coll7 (TR7 collector load)
*   R23(100K): base7 → ground (summing node reference)
*   R24(39K):  node_X → base7 (GLOBAL NEGATIVE feedback from output)
*   R26(3K3):  emit7 → ground (emitter DC path)
*   C15(100µ): emit7 → ground (emitter AC bypass → high open-loop gain)
*   C13(660p): emit7 → ground (HF bypass)
*   C12(470p): base7 → emit7 (base-emitter comp)
*   C19(47p):  base7 → coll7 (Miller comp)
*   R27(120K): coll7 → base8 (inter-stage coupling)
*   R28(180K): Vcc(L) → base8 (bias pull-up)
*   R29(180K): base8 → ground (bias pull-down) → Vbase8 ≈ 12V
*   TR8 coll:  direct to Vcc (EF, no collector load)
*   R30(3K6):  emit9 → node_X (output emitter path)
*   R31(820):  node_X → ground (ground end of feedback divider)
*   R32(3K9):  emit9 → ground (parallel DC path)
*   C24(1000p):emit9 → ground (HF bypass)
*   C25(22µ):  emit9 → Pin M (output coupling)
*
* Gain analysis:
*   Without C15: Av_open ≈ R25/R26 = 27K/3.3K = 8.2 (18 dB) — nearly open-loop
*   With C15:    Av_open ≈ gm × R25 ≈ 200+ → feedback controls gain precisely
*   Feedback fraction: R31/(R30+R31) × R23/(R24+R23) = 0.185 × 0.719 = 0.133
*   Effective Z_fb = R24 × (R30+R31)/R31 = 39K × 5.39 = 210K
*   Closed-loop gain ≈ -Z_fb/R_input = -210K/6.8K = -31 (30 dB) with C15

* ============================================================
* BA211 Passive Bridge
* ============================================================

R_b    in       center  6.8K
R_c    center   node_c  6.8K

R_lc   center   lc_top  8.2K
R_dcr  lc_top   lc_ind  32
L_pres lc_ind   lc_cap  0.2
C_pres lc_cap   pot_top 12.2N

R_pot_a pot_top  amp_out 1
R_pot_b pot_top  0       50K

* ============================================================
* BA284 Section 3: CE → EF → EF (1 inversion = inverting)
* ============================================================

* --- Input coupling ---
C18    node_c   base7   10U

* --- TR7: Common-Emitter Input Stage (only gain stage) ---
R23    base7    0       100K      ; Summing node ground reference
R24    node_x   base7   39K       ; GLOBAL NEGATIVE FB from TR9 emitter area
R25    vcc      coll7   27K       ; Collector load from +24V (Pin L)
C19    base7    coll7   47P       ; Miller compensation
C12    base7    emit7   470P      ; Base-to-emitter compensation
Q7     coll7    base7   emit7     QBC184C

* TR7 emitter — grounded at AC by C15 for high open-loop gain
R26    emit7    0       3.3K      ; DC emitter path
C15    emit7    0       100U      ; AC bypass → very high Av_open
C13    emit7    0       660P      ; HF bypass
C21    emit7    0       660P      ; Additional HF bypass

* TR7 collector
C20    coll7    0       470P      ; Collector HF bypass

* --- Inter-stage coupling to TR8 ---
R27    coll7    base8   120K      ; TR7 collector to TR8 base

* --- TR8: Emitter Follower (collector DIRECT to Vcc) ---
R28    vcc      base8   180K      ; Base bias pull-up
R29    base8    0       180K      ; Base bias pull-down (Vbase8 ≈ 12V)
C14    coll7    base8   22U       ; Decouples between R25(Vcc→coll7) and R28(Vcc→base8)
Q8     vcc      base8   emit8     QBC184C

* TR8 emitter → TR9 base (DC-coupled, like preamp TR3)
* No emitter resistor for TR8 — drives TR9 base directly

* --- TR9: Emitter Follower Output (collector DIRECT to Vcc) ---
Q9     vcc      emit8   emit9     QBC184C

* TR9 emitter: three parallel paths to ground + output coupling
R30    emit9    node_x  3.6K      ; To feedback tap node
R31    node_x   0       820       ; Ground end of feedback divider
R32    emit9    0       3.9K      ; Parallel DC emitter path
C24    emit9    0       1000P     ; HF bypass
C25    emit9    eq_out  22U       ; Output coupling to Pin M

* amp_out = emit9 for the LC/pot connection
R_out  emit9    amp_out 0.01

* Supply
C22    vcc      0       22U

* ============================================================
* External Feedback (BA211 board, on mainboard)
* ============================================================
* With inverting topology, external feedback goes to base7 (summing node).
* R_fb1(220K) from amp output to base7, in parallel with R24 feedback.
* Together they set the closed-loop gain.

R_fb1  amp_out  base7   220K      ; LF feedback to summing node
R_fb2  amp_out  fb_mid  2.7K      ; HF feedback
C_fb   fb_mid   base7   22N       ; Frequency-dependent rolloff

* ============================================================
* Output
* ============================================================
R57    eq_out   out     120
R_load out      0       10K

* ============================================================
* Supply and Models
* ============================================================
VCC    vcc      0       DC 24

.model QBC184C NPN(IS=1.8e-14 BF=420 NF=1 VAF=80
+ IKF=0.1 ISE=1e-30 NE=1.5 BR=20 NR=1 VAR=12
+ IKR=3e-4 RB=50 RE=0.5 RC=1
+ CJE=10e-12 VJE=0.7 MJE=0.33 CJC=4e-12 VJC=0.5 MJC=0.33
+ TF=5e-10 TR=1e-7)

.switch L_pres,C_pres,R_dcr 2/100N/85 1.1/47N/59 0.45/22N/35 0.2/12.2N/32 0.2/4.7N/32 0.2/2.42N/32 "Presence Freq"

.END
