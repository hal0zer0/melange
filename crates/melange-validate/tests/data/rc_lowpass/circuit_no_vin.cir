* RC Lowpass Filter (without input voltage source for solver validation)
* Simple first-order RC filter for validation testing
* Cutoff frequency: ~1.6 kHz (R=10k, C=10nF)
* Input is applied via solver's input_conductance

R1 in out 10k
C1 out 0 10n

* Control statements for transient analysis
.TRAN 1u 10m
.PRINT TRAN V(out) V(in)

.END
