* Antiparallel Diodes - Symmetric clipping
* Tests two 1D devices in 2D solver

.model D1N4148 D(IS=2.52e-9 RS=0.568 N=1.906)

* Input source - PWL will be injected during validation
VIN in 0 DC 0

R1 in out 1k
D1 out 0 D1N4148
D2 0 out D1N4148

.tran 10u 2m
.print tran V(out) V(in)
.end
