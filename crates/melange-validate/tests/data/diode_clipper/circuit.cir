* Diode Clipper Circuit
* Input -> R1 -> out -> diodes to ground, with RC at out node
* C1 provides trapezoidal rule stability

VIN in 0 DC 0 AC 1
R1 in out 1k
D1 out 0 D1N4148
D2 0 out D1N4148
C1 out 0 1u
R2 out 0 10k

* Diode model (1N4148 approx)
.MODEL D1N4148 D(IS=2.52e-9 N=1.752)

* Control statements
.TRAN 1u 10m
.PRINT TRAN V(out) V(in)

.END
