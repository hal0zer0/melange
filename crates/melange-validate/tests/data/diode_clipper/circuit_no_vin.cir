* Diode Clipper Circuit (without input voltage source for solver validation)
* Input is applied via solver's input_conductance at node 'in'

R1 in out 1k
D1 out 0 D1N4148
D2 0 out D1N4148
C1 out 0 1u
R2 out 0 10k

* Diode model (1N4148 approx)
.MODEL D1N4148 D(IS=2.52e-9 N=1.752)

.END
