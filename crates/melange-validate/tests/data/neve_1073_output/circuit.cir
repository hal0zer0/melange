* Neve 1073 Output Amplifier (BA283 AM) — SPICE Validation
* Class A, 3 BJTs: TR1/TR2 (BC184C) + TR3 (2N3055), LO1166 output transformer.
* CE input (TR1) -> Darlington CE (TR2+TR3) -> LO1166 transformer.

* --- Input (1 ohm Thevenin source for ngspice) ---
VIN   in_src  0   DC 0
R_src in_src  in  1

* --- Input coupling ---
C1    in     base1   10U

* --- TR1: CE input stage (BC184C) ---
R2    base1  0       56K

* DC feedback divider: R8 from TR1 collector, R6 to ground
R8    coll1  bias_node  33K
R6    bias_node  0      18K
RV1   bias_node  base1  2.35K

* Collector load
R3    coll1  vcc     68K
Q1    coll1  base1   emit1  QBC184C

* Miller compensation
C2    coll1  base1   220P

* Emitter degeneration (DC bias)
R5    emit1  0       3.3K
C5    emit1  0       330P

* --- Feedback network ---
C4    coll_dar  fb_node  100U
R1    fb_node   emit1    2.2K
C3    fb_node   emit1    4700P

* Gain setting: R in series with C, across R5 (25 dB balanced)
R_gain emit1    gain_mid  470
C_gain gain_mid 0         80U

* --- TR2 + TR3: Darlington CE pair ---
Q2    coll_dar  coll1    dar_mid  QBC184C
R4    dar_mid  0       1.2K
Q3    coll_dar  dar_mid  emit3  Q2N3055
R7    emit3  0       47

* --- LO1166 Output Transformer ---
* Marinair spec: L_pri=1.9H, L_sec=5.36H, ratio 1:1.68, DCR 14/44 ohm
R_dcr_pri vcc     pri_w   14
L_pri     pri_w   coll_dar 1.9
R_dcr_sec out_w   out     44
L_sec     out_w   0       5.36
K1 L_pri L_sec 0.99

* --- Output load (600 ohm) ---
R_load  out  0  600

* --- Supply ---
C6    vcc    0   100U
VCC   vcc   0   DC 24

* --- Device models ---
.model QBC184C NPN(IS=1.8e-14 BF=420 NF=1 VAF=80
+ IKF=0.1 ISE=1e-30 NE=1.5 BR=20 NR=1 VAR=12
+ IKR=3e-4 RB=50 RE=0.5 RC=1
+ CJE=10e-12 VJE=0.7 MJE=0.33 CJC=4e-12 VJC=0.5 MJC=0.33
+ TF=5e-10 TR=1e-7)

.model Q2N3055 NPN(IS=4.66e-12 BF=360 NF=1 VAF=100
+ IKF=0.25 ISE=3.34e-11 NE=1.5 BR=2 NR=1 VAR=20
+ IKR=0.01 RB=3 RE=0.01 RC=0.04
+ CJE=580e-12 VJE=1.2 MJE=0.45 CJC=212e-12 VJC=0.5 MJC=0.4
+ TF=8e-8 TR=2.55e-6)

.TRAN 1u 50m
.PRINT TRAN V(out) V(in) V(coll1) V(coll_dar) V(emit3)

.END
