Tube Screamer TS808 Wiper - SPICE Validation
* Clipping stage + tone (same as tube_screamer validation)
* Volume: 100K wiper pot baked at pos=0.85 (R_cw=15001, R_ccw=84999)
* Op-amp modeled as VCCS + Rout (matches melange OA model)

* --- Input coupling ---
Cin in n1 0.047u
R_pull n1 0 1Meg

* --- Non-inverting clipping amplifier ---
G1 0 n_clip n1 n_inv 2666.667
Rout n_clip 0 75

* --- Inverting input ground impedance ---
R4 n_inv n_gnd 4.7k
C3 n_gnd 0 0.047u

* --- Feedback path ---
R_drive n_clip n_inv 551k
D1 n_clip n_inv D1N4148
D2 n_inv n_clip D1N4148
C4 n_clip n_inv 51p

* --- Tone control ---
R_tone n_clip n_tone 5k
C5 n_tone 0 0.22u

* --- Volume (wiper at pos=0.85) ---
R_vol_cw n_tone n_vol 15001
R_vol_ccw n_vol 0 84999

* --- Output coupling ---
C_out n_vol out 10u
R_out out 0 1Meg

* --- Models ---
.model D1N4148 D(IS=2.52e-9 RS=0.568 N=1.752)

* --- Simulation ---
.OPTIONS INTERP
.TRAN 0.208333u 10m
.PRINT TRAN V(out) V(in)

.END
