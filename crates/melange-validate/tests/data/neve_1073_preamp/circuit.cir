* Neve 1073 Preamp (BA283 AV) — SPICE Validation
* Class A, 3 BJTs: TR4/TR5/TR6 (all BC184C). No output transformer.
* Topology: CE input (TR4) -> DC-coupled CE (TR5) -> EF buffer (TR6)

* --- Input (1 ohm Thevenin source for ngspice) ---
VIN   in     0      DC 0

* --- Pin U DC reference ---
R9    in     0      120K

* --- Input coupling ---
C8    in     base4  10U

* --- TR4: CE input stage (BC184C) ---
R10   base4  node_d  68K
C9    base4  coll4   100P
C10   base4  emit4   1500P
R11   vcc    mid     33K
R12   mid    coll4   47K
C12   mid    0       22U
Q4    coll4  base4  emit4  QBC184C

* --- TR4 collector DC-couples to TR5 base ---
C11   coll4  0       680P

* --- TR5: DC-coupled CE stage (BC184C) ---
R13   vcc    coll5   5.1K
Q5    coll5  coll4   emit5  QBC184C
R14   emit5  node_d  470
R15   node_d 0       1.5K
C13   node_d 0       125U
C14   emit5  pin_s   22U
R16   pin_s  0       10K

* --- TR6: Emitter follower output (BC184C) ---
Q6    vcc    coll5   emit6  QBC184C
C16   emit6  0       1000P
R17   emit6  emit4   2.2K
C15   emit6  out     22U
R20   out    0       51K

* --- Feedback / gain network ---
R18   emit4  0       390
C17   emit4  pin_t   400U
R19   pin_t  0       1.8K
R_boost pin_t 0      120

* --- External NFB ---
R_nfb  pin_s  in     18K

* --- Supply ---
VCC   vcc    0      DC 24

* --- Device models ---
.model QBC184C NPN(IS=1.8e-14 BF=420 NF=1 BR=20 NR=1
+ RB=50 RE=0.5 RC=1
+ CJE=10e-12 VJE=0.7 MJE=0.33 CJC=4e-12 VJC=0.5 MJC=0.33
+ TF=5e-10 TR=1e-7)

.TRAN 10u 500m
.PRINT TRAN V(out) V(in) V(coll4) V(coll5) V(emit4) V(emit6)

.END
